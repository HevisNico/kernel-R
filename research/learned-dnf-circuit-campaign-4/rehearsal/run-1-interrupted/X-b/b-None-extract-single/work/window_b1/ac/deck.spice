* 3 R cells, pulses at any date (phase 0 of the network experiment, exploratory)
.lib "pdk/models/sky130.lib.spice" tt
* one period at rest, K pulses on port 1, K pulses on port 2, then one pulse on both.
* Every edge of the stimulus is 0.1 us after an instant of the noise sources (sampled every 0.4 us),
* so an edge never falls on a noise sample.
.param vddv=1.8 tu=20u tper=440u t0=4.1u kp=10
.param cq=5p vunit=0.5 vr0=1.25
.param vfire={vr0 - 0.9*vunit} vreopen={vr0 - 0.1*vunit}
.param rleak={2*tu/cq} at={log(4)/tu} ipk={cq*vunit*at} ioff=50n
.param vcm=0.4 vhi=0.6 vlo=0.5 vpre=1.3 vinit=0.3895
.param cs0=400f cf0=30p idis=8.2n wg=40 lg=2.5 rlk=1e18
.option scale=1e-6
.option reltol=1e-4 abstol=1e-13 vntol=1e-7 chgtol=1e-17
* ngspice puts a conductance gmin across every junction, 1e-12 S by default. On the summing
* node of the integrator that is a leak of 0.4 pA, far above the modelled junction leakage.
.option gmin=1e-16
.model swr sw vt=0.9 vh=0.1 ron=1e6 roff=1e13
vdd vdd 0 {vddv}
vr0 vr0 0 {vr0}
vfire vfire 0 {vfire}
vreopen vreopen 0 {vreopen}
vcm vcm 0 {vcm} ac 1
vhi vhi 0 {vhi}
vlo vlo 0 {vlo}
vpre vpre 0 {vpre}
vinita1 vinita1 0 0.3895
vksa1 ksa1 0 pulse(0 1 1.0 1n 1n 1.9999e-05 2)
vkra1 kra1 0 pulse(1 0 1.0 1n 1n 0.000121 2)
vkpa1 kpa1 0 pulse(0 1 1.0 1n 1n 0.00012 2)
vtsa1 tsa1 0 dc 1.0
vampa1 ampa1 0 dc 1
vinita2 vinita2 0 0.3895
vksa2 ksa2 0 pulse(0 1 1.0 1n 1n 1.9999e-05 2)
vkra2 kra2 0 pulse(1 0 1.0 1n 1n 0.000121 2)
vkpa2 kpa2 0 pulse(0 1 1.0 1n 1n 0.00012 2)
vtsa2 tsa2 0 dc 1.0
vampa2 ampa2 0 dc 1
xa.x1.xmin 0 0 0 0 sky130_fd_pr__nfet_01v8 w={wg} l={lg} ad=7.25 as=7.25 pd=51.45 ps=51.45
xa.x1.xmout 0 0 0 0 sky130_fd_pr__nfet_01v8 w={wg} l={lg} ad=7.25 as=7.25 pd=51.45 ps=51.45
xa.x1.xnad.xmp1 0 0 0 0 sky130_fd_pr__pfet_01v8 w=1 l=0.15 ad=0.29 as=0.29 pd=2.58 ps=2.58
xa.x1.xnad.xmp2 0 0 0 0 sky130_fd_pr__pfet_01v8 w=1 l=0.15 ad=0.29 as=0.29 pd=2.58 ps=2.58
xa.x1.xnad.xmn1 0 0 0 0 sky130_fd_pr__nfet_01v8 w=0.84 l=0.15 ad=0.2436 as=0.2436 pd=2.26 ps=2.26
xa.x1.xnad.xmn2 0 0 0 0 sky130_fd_pr__nfet_01v8 w=0.84 l=0.15 ad=0.2436 as=0.2436 pd=2.26 ps=2.26
xa.x1.xiad.xmp 0 0 0 0 sky130_fd_pr__pfet_01v8 w=1 l=0.15 ad=0.29 as=0.29 pd=2.58 ps=2.58
xa.x1.xiad.xmn 0 0 0 0 sky130_fd_pr__nfet_01v8 w=0.42 l=0.15 ad=0.1218 as=0.1218 pd=1.42 ps=1.42
xa.x1.xms1 0 0 0 0 sky130_fd_pr__nfet_01v8 w=1 l=0.15 ad=0.29 as=0.29 pd=2.58 ps=2.58
xa.x1.xms2 0 0 0 0 sky130_fd_pr__nfet_01v8 w=1 l=0.15 ad=0.29 as=0.29 pd=2.58 ps=2.58
xa.x1.xmpre 0 0 0 0 sky130_fd_pr__pfet_01v8 w=2 l=0.5 ad=0.58 as=0.58 pd=4.58 ps=4.58
xa.x1.xmbd 0 0 0 0 sky130_fd_pr__nfet_01v8 w=0.42 l=8 ad=0.1218 as=0.1218 pd=1.42 ps=1.42
xa.x1.xmdis 0 0 0 0 sky130_fd_pr__nfet_01v8 w=0.42 l=8 ad=0.1218 as=0.1218 pd=1.42 ps=1.42
xa.x1.xmsi 0 0 0 0 sky130_fd_pr__nfet_01v8 w=1 l=0.15 ad=0.29 as=0.29 pd=2.58 ps=2.58
xa.x1.xmsd 0 0 0 0 sky130_fd_pr__nfet_01v8 w=1 l=0.15 ad=0.29 as=0.29 pd=2.58 ps=2.58
xa.x1.xop.xmb 0 0 0 0 sky130_fd_pr__pfet_01v8 w=8 l=2 ad=2.32 as=2.32 pd=16.58 ps=16.58
xa.x1.xop.xmt 0 0 0 0 sky130_fd_pr__pfet_01v8 w=8 l=2 ad=2.32 as=2.32 pd=16.58 ps=16.58
xa.x1.xop.xm1 0 0 0 0 sky130_fd_pr__pfet_01v8_lvt w=16 l=1 ad=3.48 as=3.48 pd=24.87 ps=24.87
xa.x1.xop.xm2 0 0 0 0 sky130_fd_pr__pfet_01v8_lvt w=16 l=1 ad=3.48 as=3.48 pd=24.87 ps=24.87
xa.x1.xop.xm3 0 0 0 0 sky130_fd_pr__nfet_01v8 w=4 l=2 ad=1.16 as=1.16 pd=8.58 ps=8.58
xa.x1.xop.xm4 0 0 0 0 sky130_fd_pr__nfet_01v8 w=4 l=2 ad=1.16 as=1.16 pd=8.58 ps=8.58
xa.x1.xop.xm5 0 0 0 0 sky130_fd_pr__nfet_01v8 w=16 l=1 ad=3.48 as=3.48 pd=24.87 ps=24.87
xa.x1.xop.xm6 0 0 0 0 sky130_fd_pr__pfet_01v8 w=32 l=2 ad=5.8 as=5.8 pd=41.45 ps=41.45
xa.x1.xcmps.xmb 0 0 0 0 sky130_fd_pr__pfet_01v8 w=8 l=2 ad=2.32 as=2.32 pd=16.58 ps=16.58
xa.x1.xcmps.xmt 0 0 0 0 sky130_fd_pr__pfet_01v8 w=16 l=2 ad=3.48 as=3.48 pd=24.87 ps=24.87
xa.x1.xcmps.xm1 0 0 0 0 sky130_fd_pr__pfet_01v8_lvt w={(4)} l={(1)} ad=1.16 as=1.16 pd=8.58 ps=8.58
xa.x1.xcmps.xm2 0 0 0 0 sky130_fd_pr__pfet_01v8_lvt w={(4)} l={(1)} ad=1.16 as=1.16 pd=8.58 ps=8.58
xa.x1.xcmps.xm3 0 0 0 0 sky130_fd_pr__nfet_01v8 w=2 l=1 ad=0.58 as=0.58 pd=4.58 ps=4.58
xa.x1.xcmps.xm4 0 0 0 0 sky130_fd_pr__nfet_01v8 w=2 l=1 ad=0.58 as=0.58 pd=4.58 ps=4.58
xa.x1.xcmps.xm5 0 0 0 0 sky130_fd_pr__nfet_01v8 w=2 l=0.5 ad=0.58 as=0.58 pd=4.58 ps=4.58
xa.x1.xcmps.xm6 0 0 0 0 sky130_fd_pr__pfet_01v8 w=16 l=2 ad=3.48 as=3.48 pd=24.87 ps=24.87
xa.x1.xcmps.xi1.xmp 0 0 0 0 sky130_fd_pr__pfet_01v8 w=1 l=0.15 ad=0.29 as=0.29 pd=2.58 ps=2.58
xa.x1.xcmps.xi1.xmn 0 0 0 0 sky130_fd_pr__nfet_01v8 w=0.42 l=0.15 ad=0.1218 as=0.1218 pd=1.42 ps=1.42
xa.x1.xcmps.xi2.xmp 0 0 0 0 sky130_fd_pr__pfet_01v8 w=1 l=0.15 ad=0.29 as=0.29 pd=2.58 ps=2.58
xa.x1.xcmps.xi2.xmn 0 0 0 0 sky130_fd_pr__nfet_01v8 w=0.42 l=0.15 ad=0.1218 as=0.1218 pd=1.42 ps=1.42
xa.x1.xmr1n 0 0 0 0 sky130_fd_pr__nfet_01v8 w=1 l=0.15 ad=0.29 as=0.29 pd=2.58 ps=2.58
xa.x1.xmr1p 0 0 0 0 sky130_fd_pr__pfet_01v8 w=2 l=0.15 ad=0.58 as=0.58 pd=4.58 ps=4.58
xa.x1.xmr2n 0 0 0 0 sky130_fd_pr__nfet_01v8 w=1 l=0.15 ad=0.29 as=0.29 pd=2.58 ps=2.58
xa.x1.xmr2p 0 0 0 0 sky130_fd_pr__pfet_01v8 w=2 l=0.15 ad=0.58 as=0.58 pd=4.58 ps=4.58
xa.x1.xien.xmp 0 0 0 0 sky130_fd_pr__pfet_01v8 w=1 l=0.15 ad=0.29 as=0.29 pd=2.58 ps=2.58
xa.x1.xien.xmn 0 0 0 0 sky130_fd_pr__nfet_01v8 w=0.42 l=0.15 ad=0.1218 as=0.1218 pd=1.42 ps=1.42
xa.x1.xicb.xmp 0 0 0 0 sky130_fd_pr__pfet_01v8 w=1 l=0.15 ad=0.29 as=0.29 pd=2.58 ps=2.58
xa.x1.xicb.xmn 0 0 0 0 sky130_fd_pr__nfet_01v8 w=0.42 l=0.15 ad=0.1218 as=0.1218 pd=1.42 ps=1.42
xa.x1.xnsa.xmp1 0 0 0 0 sky130_fd_pr__pfet_01v8 w=1 l=0.15 ad=0.29 as=0.29 pd=2.58 ps=2.58
xa.x1.xnsa.xmp2 0 0 0 0 sky130_fd_pr__pfet_01v8 w=1 l=0.15 ad=0.29 as=0.29 pd=2.58 ps=2.58
xa.x1.xnsa.xmn1 0 0 0 0 sky130_fd_pr__nfet_01v8 w=0.84 l=0.15 ad=0.2436 as=0.2436 pd=2.26 ps=2.26
xa.x1.xnsa.xmn2 0 0 0 0 sky130_fd_pr__nfet_01v8 w=0.84 l=0.15 ad=0.2436 as=0.2436 pd=2.26 ps=2.26
xa.x1.xla.x1.xmp1 0 0 0 0 sky130_fd_pr__pfet_01v8 w=1 l=0.15 ad=0.29 as=0.29 pd=2.58 ps=2.58
xa.x1.xla.x1.xmp2 0 0 0 0 sky130_fd_pr__pfet_01v8 w=1 l=0.15 ad=0.29 as=0.29 pd=2.58 ps=2.58
xa.x1.xla.x1.xmn1 0 0 0 0 sky130_fd_pr__nfet_01v8 w=0.84 l=0.15 ad=0.2436 as=0.2436 pd=2.26 ps=2.26
xa.x1.xla.x1.xmn2 0 0 0 0 sky130_fd_pr__nfet_01v8 w=0.84 l=0.15 ad=0.2436 as=0.2436 pd=2.26 ps=2.26
xa.x1.xla.x2.xmp1 0 0 0 0 sky130_fd_pr__pfet_01v8 w=1 l=0.15 ad=0.29 as=0.29 pd=2.58 ps=2.58
xa.x1.xla.x2.xmp2 0 0 0 0 sky130_fd_pr__pfet_01v8 w=1 l=0.15 ad=0.29 as=0.29 pd=2.58 ps=2.58
xa.x1.xla.x2.xmn1 0 0 0 0 sky130_fd_pr__nfet_01v8 w=0.84 l=0.15 ad=0.2436 as=0.2436 pd=2.26 ps=2.26
xa.x1.xla.x2.xmn2 0 0 0 0 sky130_fd_pr__nfet_01v8 w=0.84 l=0.15 ad=0.2436 as=0.2436 pd=2.26 ps=2.26
xa.x1.xia1.xmp 0 0 0 0 sky130_fd_pr__pfet_01v8 w=1 l=0.15 ad=0.29 as=0.29 pd=2.58 ps=2.58
xa.x1.xia1.xmn 0 0 0 0 sky130_fd_pr__nfet_01v8 w=0.42 l=0.15 ad=0.1218 as=0.1218 pd=1.42 ps=1.42
xa.x1.xia2.xmp 0 0 0 0 sky130_fd_pr__pfet_01v8 w=1 l=0.15 ad=0.29 as=0.29 pd=2.58 ps=2.58
xa.x1.xia2.xmn 0 0 0 0 sky130_fd_pr__nfet_01v8 w=0.42 l=0.15 ad=0.1218 as=0.1218 pd=1.42 ps=1.42
xa.x1.xnsc.xmp1 0 0 0 0 sky130_fd_pr__pfet_01v8 w=1 l=0.15 ad=0.29 as=0.29 pd=2.58 ps=2.58
xa.x1.xnsc.xmp2 0 0 0 0 sky130_fd_pr__pfet_01v8 w=1 l=0.15 ad=0.29 as=0.29 pd=2.58 ps=2.58
xa.x1.xnsc.xmn1 0 0 0 0 sky130_fd_pr__nfet_01v8 w=0.84 l=0.15 ad=0.2436 as=0.2436 pd=2.26 ps=2.26
xa.x1.xnsc.xmn2 0 0 0 0 sky130_fd_pr__nfet_01v8 w=0.84 l=0.15 ad=0.2436 as=0.2436 pd=2.26 ps=2.26
xa.x1.xlc.x1.xmp1 0 0 0 0 sky130_fd_pr__pfet_01v8 w=1 l=0.15 ad=0.29 as=0.29 pd=2.58 ps=2.58
xa.x1.xlc.x1.xmp2 0 0 0 0 sky130_fd_pr__pfet_01v8 w=1 l=0.15 ad=0.29 as=0.29 pd=2.58 ps=2.58
xa.x1.xlc.x1.xmn1 0 0 0 0 sky130_fd_pr__nfet_01v8 w=0.84 l=0.15 ad=0.2436 as=0.2436 pd=2.26 ps=2.26
xa.x1.xlc.x1.xmn2 0 0 0 0 sky130_fd_pr__nfet_01v8 w=0.84 l=0.15 ad=0.2436 as=0.2436 pd=2.26 ps=2.26
xa.x1.xlc.x2.xmp1 0 0 0 0 sky130_fd_pr__pfet_01v8 w=1 l=0.15 ad=0.29 as=0.29 pd=2.58 ps=2.58
xa.x1.xlc.x2.xmp2 0 0 0 0 sky130_fd_pr__pfet_01v8 w=1 l=0.15 ad=0.29 as=0.29 pd=2.58 ps=2.58
xa.x1.xlc.x2.xmn1 0 0 0 0 sky130_fd_pr__nfet_01v8 w=0.84 l=0.15 ad=0.2436 as=0.2436 pd=2.26 ps=2.26
xa.x1.xlc.x2.xmn2 0 0 0 0 sky130_fd_pr__nfet_01v8 w=0.84 l=0.15 ad=0.2436 as=0.2436 pd=2.26 ps=2.26
xa.x1.xid1.xmp 0 0 0 0 sky130_fd_pr__pfet_01v8 w=1 l=0.15 ad=0.29 as=0.29 pd=2.58 ps=2.58
xa.x1.xid1.xmn 0 0 0 0 sky130_fd_pr__nfet_01v8 w=0.42 l=0.15 ad=0.1218 as=0.1218 pd=1.42 ps=1.42
xa.x1.xid2.xmp 0 0 0 0 sky130_fd_pr__pfet_01v8 w=1 l=0.15 ad=0.29 as=0.29 pd=2.58 ps=2.58
xa.x1.xid2.xmn 0 0 0 0 sky130_fd_pr__nfet_01v8 w=0.42 l=0.15 ad=0.1218 as=0.1218 pd=1.42 ps=1.42
xa.x1.xnsb.xmp1 0 0 0 0 sky130_fd_pr__pfet_01v8 w=1 l=0.15 ad=0.29 as=0.29 pd=2.58 ps=2.58
xa.x1.xnsb.xmp2 0 0 0 0 sky130_fd_pr__pfet_01v8 w=1 l=0.15 ad=0.29 as=0.29 pd=2.58 ps=2.58
xa.x1.xnsb.xmn1 0 0 0 0 sky130_fd_pr__nfet_01v8 w=0.84 l=0.15 ad=0.2436 as=0.2436 pd=2.26 ps=2.26
xa.x1.xnsb.xmn2 0 0 0 0 sky130_fd_pr__nfet_01v8 w=0.84 l=0.15 ad=0.2436 as=0.2436 pd=2.26 ps=2.26
xa.x1.xlb.x1.xmp1 0 0 0 0 sky130_fd_pr__pfet_01v8 w=1 l=0.15 ad=0.29 as=0.29 pd=2.58 ps=2.58
xa.x1.xlb.x1.xmp2 0 0 0 0 sky130_fd_pr__pfet_01v8 w=1 l=0.15 ad=0.29 as=0.29 pd=2.58 ps=2.58
xa.x1.xlb.x1.xmn1 0 0 0 0 sky130_fd_pr__nfet_01v8 w=0.84 l=0.15 ad=0.2436 as=0.2436 pd=2.26 ps=2.26
xa.x1.xlb.x1.xmn2 0 0 0 0 sky130_fd_pr__nfet_01v8 w=0.84 l=0.15 ad=0.2436 as=0.2436 pd=2.26 ps=2.26
xa.x1.xlb.x2.xmp1 0 0 0 0 sky130_fd_pr__pfet_01v8 w=1 l=0.15 ad=0.29 as=0.29 pd=2.58 ps=2.58
xa.x1.xlb.x2.xmp2 0 0 0 0 sky130_fd_pr__pfet_01v8 w=1 l=0.15 ad=0.29 as=0.29 pd=2.58 ps=2.58
xa.x1.xlb.x2.xmn1 0 0 0 0 sky130_fd_pr__nfet_01v8 w=0.84 l=0.15 ad=0.2436 as=0.2436 pd=2.26 ps=2.26
xa.x1.xlb.x2.xmn2 0 0 0 0 sky130_fd_pr__nfet_01v8 w=0.84 l=0.15 ad=0.2436 as=0.2436 pd=2.26 ps=2.26
xa.x1.xnsi.xmp1 0 0 0 0 sky130_fd_pr__pfet_01v8 w=1 l=0.15 ad=0.29 as=0.29 pd=2.58 ps=2.58
xa.x1.xnsi.xmp2 0 0 0 0 sky130_fd_pr__pfet_01v8 w=1 l=0.15 ad=0.29 as=0.29 pd=2.58 ps=2.58
xa.x1.xnsi.xmp3 0 0 0 0 sky130_fd_pr__pfet_01v8 w=1 l=0.15 ad=0.29 as=0.29 pd=2.58 ps=2.58
xa.x1.xnsi.xmn1 0 0 0 0 sky130_fd_pr__nfet_01v8 w=1.26 l=0.15 ad=0.3654 as=0.3654 pd=3.1 ps=3.1
xa.x1.xnsi.xmn2 0 0 0 0 sky130_fd_pr__nfet_01v8 w=1.26 l=0.15 ad=0.3654 as=0.3654 pd=3.1 ps=3.1
xa.x1.xnsi.xmn3 0 0 0 0 sky130_fd_pr__nfet_01v8 w=1.26 l=0.15 ad=0.3654 as=0.3654 pd=3.1 ps=3.1
xa.x1.xisi.xmp 0 0 0 0 sky130_fd_pr__pfet_01v8 w=1 l=0.15 ad=0.29 as=0.29 pd=2.58 ps=2.58
xa.x1.xisi.xmn 0 0 0 0 sky130_fd_pr__nfet_01v8 w=0.42 l=0.15 ad=0.1218 as=0.1218 pd=1.42 ps=1.42
xa.x1.xisd.xmp 0 0 0 0 sky130_fd_pr__pfet_01v8 w=1 l=0.15 ad=0.29 as=0.29 pd=2.58 ps=2.58
xa.x1.xisd.xmn 0 0 0 0 sky130_fd_pr__nfet_01v8 w=0.42 l=0.15 ad=0.1218 as=0.1218 pd=1.42 ps=1.42
xa.x2.xmin 0 0 0 0 sky130_fd_pr__nfet_01v8 w={wg} l={lg} ad=7.25 as=7.25 pd=51.45 ps=51.45
xa.x2.xmout 0 0 0 0 sky130_fd_pr__nfet_01v8 w={wg} l={lg} ad=7.25 as=7.25 pd=51.45 ps=51.45
xa.x2.xnad.xmp1 0 0 0 0 sky130_fd_pr__pfet_01v8 w=1 l=0.15 ad=0.29 as=0.29 pd=2.58 ps=2.58
xa.x2.xnad.xmp2 0 0 0 0 sky130_fd_pr__pfet_01v8 w=1 l=0.15 ad=0.29 as=0.29 pd=2.58 ps=2.58
xa.x2.xnad.xmn1 0 0 0 0 sky130_fd_pr__nfet_01v8 w=0.84 l=0.15 ad=0.2436 as=0.2436 pd=2.26 ps=2.26
xa.x2.xnad.xmn2 0 0 0 0 sky130_fd_pr__nfet_01v8 w=0.84 l=0.15 ad=0.2436 as=0.2436 pd=2.26 ps=2.26
xa.x2.xiad.xmp 0 0 0 0 sky130_fd_pr__pfet_01v8 w=1 l=0.15 ad=0.29 as=0.29 pd=2.58 ps=2.58
xa.x2.xiad.xmn 0 0 0 0 sky130_fd_pr__nfet_01v8 w=0.42 l=0.15 ad=0.1218 as=0.1218 pd=1.42 ps=1.42
xa.x2.xms1 0 0 0 0 sky130_fd_pr__nfet_01v8 w=1 l=0.15 ad=0.29 as=0.29 pd=2.58 ps=2.58
xa.x2.xms2 0 0 0 0 sky130_fd_pr__nfet_01v8 w=1 l=0.15 ad=0.29 as=0.29 pd=2.58 ps=2.58
xa.x2.xmpre 0 0 0 0 sky130_fd_pr__pfet_01v8 w=2 l=0.5 ad=0.58 as=0.58 pd=4.58 ps=4.58
xa.x2.xmbd 0 0 0 0 sky130_fd_pr__nfet_01v8 w=0.42 l=8 ad=0.1218 as=0.1218 pd=1.42 ps=1.42
xa.x2.xmdis 0 0 0 0 sky130_fd_pr__nfet_01v8 w=0.42 l=8 ad=0.1218 as=0.1218 pd=1.42 ps=1.42
xa.x2.xmsi 0 0 0 0 sky130_fd_pr__nfet_01v8 w=1 l=0.15 ad=0.29 as=0.29 pd=2.58 ps=2.58
xa.x2.xmsd 0 0 0 0 sky130_fd_pr__nfet_01v8 w=1 l=0.15 ad=0.29 as=0.29 pd=2.58 ps=2.58
xa.x2.xop.xmb 0 0 0 0 sky130_fd_pr__pfet_01v8 w=8 l=2 ad=2.32 as=2.32 pd=16.58 ps=16.58
xa.x2.xop.xmt 0 0 0 0 sky130_fd_pr__pfet_01v8 w=8 l=2 ad=2.32 as=2.32 pd=16.58 ps=16.58
xa.x2.xop.xm1 0 0 0 0 sky130_fd_pr__pfet_01v8_lvt w=16 l=1 ad=3.48 as=3.48 pd=24.87 ps=24.87
xa.x2.xop.xm2 0 0 0 0 sky130_fd_pr__pfet_01v8_lvt w=16 l=1 ad=3.48 as=3.48 pd=24.87 ps=24.87
xa.x2.xop.xm3 0 0 0 0 sky130_fd_pr__nfet_01v8 w=4 l=2 ad=1.16 as=1.16 pd=8.58 ps=8.58
xa.x2.xop.xm4 0 0 0 0 sky130_fd_pr__nfet_01v8 w=4 l=2 ad=1.16 as=1.16 pd=8.58 ps=8.58
xa.x2.xop.xm5 0 0 0 0 sky130_fd_pr__nfet_01v8 w=16 l=1 ad=3.48 as=3.48 pd=24.87 ps=24.87
xa.x2.xop.xm6 0 0 0 0 sky130_fd_pr__pfet_01v8 w=32 l=2 ad=5.8 as=5.8 pd=41.45 ps=41.45
xa.x2.xcmps.xmb 0 0 0 0 sky130_fd_pr__pfet_01v8 w=8 l=2 ad=2.32 as=2.32 pd=16.58 ps=16.58
xa.x2.xcmps.xmt 0 0 0 0 sky130_fd_pr__pfet_01v8 w=16 l=2 ad=3.48 as=3.48 pd=24.87 ps=24.87
xa.x2.xcmps.xm1 0 0 0 0 sky130_fd_pr__pfet_01v8_lvt w={(4)} l={(1)} ad=1.16 as=1.16 pd=8.58 ps=8.58
xa.x2.xcmps.xm2 0 0 0 0 sky130_fd_pr__pfet_01v8_lvt w={(4)} l={(1)} ad=1.16 as=1.16 pd=8.58 ps=8.58
xa.x2.xcmps.xm3 0 0 0 0 sky130_fd_pr__nfet_01v8 w=2 l=1 ad=0.58 as=0.58 pd=4.58 ps=4.58
xa.x2.xcmps.xm4 0 0 0 0 sky130_fd_pr__nfet_01v8 w=2 l=1 ad=0.58 as=0.58 pd=4.58 ps=4.58
xa.x2.xcmps.xm5 0 0 0 0 sky130_fd_pr__nfet_01v8 w=2 l=0.5 ad=0.58 as=0.58 pd=4.58 ps=4.58
xa.x2.xcmps.xm6 0 0 0 0 sky130_fd_pr__pfet_01v8 w=16 l=2 ad=3.48 as=3.48 pd=24.87 ps=24.87
xa.x2.xcmps.xi1.xmp 0 0 0 0 sky130_fd_pr__pfet_01v8 w=1 l=0.15 ad=0.29 as=0.29 pd=2.58 ps=2.58
xa.x2.xcmps.xi1.xmn 0 0 0 0 sky130_fd_pr__nfet_01v8 w=0.42 l=0.15 ad=0.1218 as=0.1218 pd=1.42 ps=1.42
xa.x2.xcmps.xi2.xmp 0 0 0 0 sky130_fd_pr__pfet_01v8 w=1 l=0.15 ad=0.29 as=0.29 pd=2.58 ps=2.58
xa.x2.xcmps.xi2.xmn 0 0 0 0 sky130_fd_pr__nfet_01v8 w=0.42 l=0.15 ad=0.1218 as=0.1218 pd=1.42 ps=1.42
xa.x2.xmr1n 0 0 0 0 sky130_fd_pr__nfet_01v8 w=1 l=0.15 ad=0.29 as=0.29 pd=2.58 ps=2.58
xa.x2.xmr1p 0 0 0 0 sky130_fd_pr__pfet_01v8 w=2 l=0.15 ad=0.58 as=0.58 pd=4.58 ps=4.58
xa.x2.xmr2n 0 0 0 0 sky130_fd_pr__nfet_01v8 w=1 l=0.15 ad=0.29 as=0.29 pd=2.58 ps=2.58
xa.x2.xmr2p 0 0 0 0 sky130_fd_pr__pfet_01v8 w=2 l=0.15 ad=0.58 as=0.58 pd=4.58 ps=4.58
xa.x2.xien.xmp 0 0 0 0 sky130_fd_pr__pfet_01v8 w=1 l=0.15 ad=0.29 as=0.29 pd=2.58 ps=2.58
xa.x2.xien.xmn 0 0 0 0 sky130_fd_pr__nfet_01v8 w=0.42 l=0.15 ad=0.1218 as=0.1218 pd=1.42 ps=1.42
xa.x2.xicb.xmp 0 0 0 0 sky130_fd_pr__pfet_01v8 w=1 l=0.15 ad=0.29 as=0.29 pd=2.58 ps=2.58
xa.x2.xicb.xmn 0 0 0 0 sky130_fd_pr__nfet_01v8 w=0.42 l=0.15 ad=0.1218 as=0.1218 pd=1.42 ps=1.42
xa.x2.xnsa.xmp1 0 0 0 0 sky130_fd_pr__pfet_01v8 w=1 l=0.15 ad=0.29 as=0.29 pd=2.58 ps=2.58
xa.x2.xnsa.xmp2 0 0 0 0 sky130_fd_pr__pfet_01v8 w=1 l=0.15 ad=0.29 as=0.29 pd=2.58 ps=2.58
xa.x2.xnsa.xmn1 0 0 0 0 sky130_fd_pr__nfet_01v8 w=0.84 l=0.15 ad=0.2436 as=0.2436 pd=2.26 ps=2.26
xa.x2.xnsa.xmn2 0 0 0 0 sky130_fd_pr__nfet_01v8 w=0.84 l=0.15 ad=0.2436 as=0.2436 pd=2.26 ps=2.26
xa.x2.xla.x1.xmp1 0 0 0 0 sky130_fd_pr__pfet_01v8 w=1 l=0.15 ad=0.29 as=0.29 pd=2.58 ps=2.58
xa.x2.xla.x1.xmp2 0 0 0 0 sky130_fd_pr__pfet_01v8 w=1 l=0.15 ad=0.29 as=0.29 pd=2.58 ps=2.58
xa.x2.xla.x1.xmn1 0 0 0 0 sky130_fd_pr__nfet_01v8 w=0.84 l=0.15 ad=0.2436 as=0.2436 pd=2.26 ps=2.26
xa.x2.xla.x1.xmn2 0 0 0 0 sky130_fd_pr__nfet_01v8 w=0.84 l=0.15 ad=0.2436 as=0.2436 pd=2.26 ps=2.26
xa.x2.xla.x2.xmp1 0 0 0 0 sky130_fd_pr__pfet_01v8 w=1 l=0.15 ad=0.29 as=0.29 pd=2.58 ps=2.58
xa.x2.xla.x2.xmp2 0 0 0 0 sky130_fd_pr__pfet_01v8 w=1 l=0.15 ad=0.29 as=0.29 pd=2.58 ps=2.58
xa.x2.xla.x2.xmn1 0 0 0 0 sky130_fd_pr__nfet_01v8 w=0.84 l=0.15 ad=0.2436 as=0.2436 pd=2.26 ps=2.26
xa.x2.xla.x2.xmn2 0 0 0 0 sky130_fd_pr__nfet_01v8 w=0.84 l=0.15 ad=0.2436 as=0.2436 pd=2.26 ps=2.26
xa.x2.xia1.xmp 0 0 0 0 sky130_fd_pr__pfet_01v8 w=1 l=0.15 ad=0.29 as=0.29 pd=2.58 ps=2.58
xa.x2.xia1.xmn 0 0 0 0 sky130_fd_pr__nfet_01v8 w=0.42 l=0.15 ad=0.1218 as=0.1218 pd=1.42 ps=1.42
xa.x2.xia2.xmp 0 0 0 0 sky130_fd_pr__pfet_01v8 w=1 l=0.15 ad=0.29 as=0.29 pd=2.58 ps=2.58
xa.x2.xia2.xmn 0 0 0 0 sky130_fd_pr__nfet_01v8 w=0.42 l=0.15 ad=0.1218 as=0.1218 pd=1.42 ps=1.42
xa.x2.xnsc.xmp1 0 0 0 0 sky130_fd_pr__pfet_01v8 w=1 l=0.15 ad=0.29 as=0.29 pd=2.58 ps=2.58
xa.x2.xnsc.xmp2 0 0 0 0 sky130_fd_pr__pfet_01v8 w=1 l=0.15 ad=0.29 as=0.29 pd=2.58 ps=2.58
xa.x2.xnsc.xmn1 0 0 0 0 sky130_fd_pr__nfet_01v8 w=0.84 l=0.15 ad=0.2436 as=0.2436 pd=2.26 ps=2.26
xa.x2.xnsc.xmn2 0 0 0 0 sky130_fd_pr__nfet_01v8 w=0.84 l=0.15 ad=0.2436 as=0.2436 pd=2.26 ps=2.26
xa.x2.xlc.x1.xmp1 0 0 0 0 sky130_fd_pr__pfet_01v8 w=1 l=0.15 ad=0.29 as=0.29 pd=2.58 ps=2.58
xa.x2.xlc.x1.xmp2 0 0 0 0 sky130_fd_pr__pfet_01v8 w=1 l=0.15 ad=0.29 as=0.29 pd=2.58 ps=2.58
xa.x2.xlc.x1.xmn1 0 0 0 0 sky130_fd_pr__nfet_01v8 w=0.84 l=0.15 ad=0.2436 as=0.2436 pd=2.26 ps=2.26
xa.x2.xlc.x1.xmn2 0 0 0 0 sky130_fd_pr__nfet_01v8 w=0.84 l=0.15 ad=0.2436 as=0.2436 pd=2.26 ps=2.26
xa.x2.xlc.x2.xmp1 0 0 0 0 sky130_fd_pr__pfet_01v8 w=1 l=0.15 ad=0.29 as=0.29 pd=2.58 ps=2.58
xa.x2.xlc.x2.xmp2 0 0 0 0 sky130_fd_pr__pfet_01v8 w=1 l=0.15 ad=0.29 as=0.29 pd=2.58 ps=2.58
xa.x2.xlc.x2.xmn1 0 0 0 0 sky130_fd_pr__nfet_01v8 w=0.84 l=0.15 ad=0.2436 as=0.2436 pd=2.26 ps=2.26
xa.x2.xlc.x2.xmn2 0 0 0 0 sky130_fd_pr__nfet_01v8 w=0.84 l=0.15 ad=0.2436 as=0.2436 pd=2.26 ps=2.26
xa.x2.xid1.xmp 0 0 0 0 sky130_fd_pr__pfet_01v8 w=1 l=0.15 ad=0.29 as=0.29 pd=2.58 ps=2.58
xa.x2.xid1.xmn 0 0 0 0 sky130_fd_pr__nfet_01v8 w=0.42 l=0.15 ad=0.1218 as=0.1218 pd=1.42 ps=1.42
xa.x2.xid2.xmp 0 0 0 0 sky130_fd_pr__pfet_01v8 w=1 l=0.15 ad=0.29 as=0.29 pd=2.58 ps=2.58
xa.x2.xid2.xmn 0 0 0 0 sky130_fd_pr__nfet_01v8 w=0.42 l=0.15 ad=0.1218 as=0.1218 pd=1.42 ps=1.42
xa.x2.xnsb.xmp1 0 0 0 0 sky130_fd_pr__pfet_01v8 w=1 l=0.15 ad=0.29 as=0.29 pd=2.58 ps=2.58
xa.x2.xnsb.xmp2 0 0 0 0 sky130_fd_pr__pfet_01v8 w=1 l=0.15 ad=0.29 as=0.29 pd=2.58 ps=2.58
xa.x2.xnsb.xmn1 0 0 0 0 sky130_fd_pr__nfet_01v8 w=0.84 l=0.15 ad=0.2436 as=0.2436 pd=2.26 ps=2.26
xa.x2.xnsb.xmn2 0 0 0 0 sky130_fd_pr__nfet_01v8 w=0.84 l=0.15 ad=0.2436 as=0.2436 pd=2.26 ps=2.26
xa.x2.xlb.x1.xmp1 0 0 0 0 sky130_fd_pr__pfet_01v8 w=1 l=0.15 ad=0.29 as=0.29 pd=2.58 ps=2.58
xa.x2.xlb.x1.xmp2 0 0 0 0 sky130_fd_pr__pfet_01v8 w=1 l=0.15 ad=0.29 as=0.29 pd=2.58 ps=2.58
xa.x2.xlb.x1.xmn1 0 0 0 0 sky130_fd_pr__nfet_01v8 w=0.84 l=0.15 ad=0.2436 as=0.2436 pd=2.26 ps=2.26
xa.x2.xlb.x1.xmn2 0 0 0 0 sky130_fd_pr__nfet_01v8 w=0.84 l=0.15 ad=0.2436 as=0.2436 pd=2.26 ps=2.26
xa.x2.xlb.x2.xmp1 0 0 0 0 sky130_fd_pr__pfet_01v8 w=1 l=0.15 ad=0.29 as=0.29 pd=2.58 ps=2.58
xa.x2.xlb.x2.xmp2 0 0 0 0 sky130_fd_pr__pfet_01v8 w=1 l=0.15 ad=0.29 as=0.29 pd=2.58 ps=2.58
xa.x2.xlb.x2.xmn1 0 0 0 0 sky130_fd_pr__nfet_01v8 w=0.84 l=0.15 ad=0.2436 as=0.2436 pd=2.26 ps=2.26
xa.x2.xlb.x2.xmn2 0 0 0 0 sky130_fd_pr__nfet_01v8 w=0.84 l=0.15 ad=0.2436 as=0.2436 pd=2.26 ps=2.26
xa.x2.xnsi.xmp1 0 0 0 0 sky130_fd_pr__pfet_01v8 w=1 l=0.15 ad=0.29 as=0.29 pd=2.58 ps=2.58
xa.x2.xnsi.xmp2 0 0 0 0 sky130_fd_pr__pfet_01v8 w=1 l=0.15 ad=0.29 as=0.29 pd=2.58 ps=2.58
xa.x2.xnsi.xmp3 0 0 0 0 sky130_fd_pr__pfet_01v8 w=1 l=0.15 ad=0.29 as=0.29 pd=2.58 ps=2.58
xa.x2.xnsi.xmn1 0 0 0 0 sky130_fd_pr__nfet_01v8 w=1.26 l=0.15 ad=0.3654 as=0.3654 pd=3.1 ps=3.1
xa.x2.xnsi.xmn2 0 0 0 0 sky130_fd_pr__nfet_01v8 w=1.26 l=0.15 ad=0.3654 as=0.3654 pd=3.1 ps=3.1
xa.x2.xnsi.xmn3 0 0 0 0 sky130_fd_pr__nfet_01v8 w=1.26 l=0.15 ad=0.3654 as=0.3654 pd=3.1 ps=3.1
xa.x2.xisi.xmp 0 0 0 0 sky130_fd_pr__pfet_01v8 w=1 l=0.15 ad=0.29 as=0.29 pd=2.58 ps=2.58
xa.x2.xisi.xmn 0 0 0 0 sky130_fd_pr__nfet_01v8 w=0.42 l=0.15 ad=0.1218 as=0.1218 pd=1.42 ps=1.42
xa.x2.xisd.xmp 0 0 0 0 sky130_fd_pr__pfet_01v8 w=1 l=0.15 ad=0.29 as=0.29 pd=2.58 ps=2.58
xa.x2.xisd.xmn 0 0 0 0 sky130_fd_pr__nfet_01v8 w=0.42 l=0.15 ad=0.1218 as=0.1218 pd=1.42 ps=1.42
xa.xcmpm.xmb 0 0 0 0 sky130_fd_pr__pfet_01v8 w=8 l=2 ad=2.32 as=2.32 pd=16.58 ps=16.58
xa.xcmpm.xmt 0 0 0 0 sky130_fd_pr__pfet_01v8 w=16 l=2 ad=3.48 as=3.48 pd=24.87 ps=24.87
xa.xcmpm.xm1 0 0 0 0 sky130_fd_pr__pfet_01v8_lvt w={(16)} l={(4)} ad=3.48 as=3.48 pd=24.87 ps=24.87
xa.xcmpm.xm2 0 0 0 0 sky130_fd_pr__pfet_01v8_lvt w={(16)} l={(4)} ad=3.48 as=3.48 pd=24.87 ps=24.87
xa.xcmpm.xm3 0 0 0 0 sky130_fd_pr__nfet_01v8 w=2 l=1 ad=0.58 as=0.58 pd=4.58 ps=4.58
xa.xcmpm.xm4 0 0 0 0 sky130_fd_pr__nfet_01v8 w=2 l=1 ad=0.58 as=0.58 pd=4.58 ps=4.58
xa.xcmpm.xm5 0 0 0 0 sky130_fd_pr__nfet_01v8 w=2 l=0.5 ad=0.58 as=0.58 pd=4.58 ps=4.58
xa.xcmpm.xm6 0 0 0 0 sky130_fd_pr__pfet_01v8 w=16 l=2 ad=3.48 as=3.48 pd=24.87 ps=24.87
xa.xcmpm.xi1.xmp 0 0 0 0 sky130_fd_pr__pfet_01v8 w=1 l=0.15 ad=0.29 as=0.29 pd=2.58 ps=2.58
xa.xcmpm.xi1.xmn 0 0 0 0 sky130_fd_pr__nfet_01v8 w=0.42 l=0.15 ad=0.1218 as=0.1218 pd=1.42 ps=1.42
xa.xcmpm.xi2.xmp 0 0 0 0 sky130_fd_pr__pfet_01v8 w=1 l=0.15 ad=0.29 as=0.29 pd=2.58 ps=2.58
xa.xcmpm.xi2.xmn 0 0 0 0 sky130_fd_pr__nfet_01v8 w=0.42 l=0.15 ad=0.1218 as=0.1218 pd=1.42 ps=1.42
xa.xicm.xmp 0 0 0 0 sky130_fd_pr__pfet_01v8 w=1 l=0.15 ad=0.29 as=0.29 pd=2.58 ps=2.58
xa.xicm.xmn 0 0 0 0 sky130_fd_pr__nfet_01v8 w=0.42 l=0.15 ad=0.1218 as=0.1218 pd=1.42 ps=1.42
xa.xnsp.xmp1 0 0 0 0 sky130_fd_pr__pfet_01v8 w=1 l=0.15 ad=0.29 as=0.29 pd=2.58 ps=2.58
xa.xnsp.xmp2 0 0 0 0 sky130_fd_pr__pfet_01v8 w=1 l=0.15 ad=0.29 as=0.29 pd=2.58 ps=2.58
xa.xnsp.xmn1 0 0 0 0 sky130_fd_pr__nfet_01v8 w=0.84 l=0.15 ad=0.2436 as=0.2436 pd=2.26 ps=2.26
xa.xnsp.xmn2 0 0 0 0 sky130_fd_pr__nfet_01v8 w=0.84 l=0.15 ad=0.2436 as=0.2436 pd=2.26 ps=2.26
xa.xnrp.xmp1 0 0 0 0 sky130_fd_pr__pfet_01v8 w=1 l=0.15 ad=0.29 as=0.29 pd=2.58 ps=2.58
xa.xnrp.xmp2 0 0 0 0 sky130_fd_pr__pfet_01v8 w=1 l=0.15 ad=0.29 as=0.29 pd=2.58 ps=2.58
xa.xnrp.xmn1 0 0 0 0 sky130_fd_pr__nfet_01v8 w=0.84 l=0.15 ad=0.2436 as=0.2436 pd=2.26 ps=2.26
xa.xnrp.xmn2 0 0 0 0 sky130_fd_pr__nfet_01v8 w=0.84 l=0.15 ad=0.2436 as=0.2436 pd=2.26 ps=2.26
xa.xlp.x1.xmp1 0 0 0 0 sky130_fd_pr__pfet_01v8 w=1 l=0.15 ad=0.29 as=0.29 pd=2.58 ps=2.58
xa.xlp.x1.xmp2 0 0 0 0 sky130_fd_pr__pfet_01v8 w=1 l=0.15 ad=0.29 as=0.29 pd=2.58 ps=2.58
xa.xlp.x1.xmn1 0 0 0 0 sky130_fd_pr__nfet_01v8 w=0.84 l=0.15 ad=0.2436 as=0.2436 pd=2.26 ps=2.26
xa.xlp.x1.xmn2 0 0 0 0 sky130_fd_pr__nfet_01v8 w=0.84 l=0.15 ad=0.2436 as=0.2436 pd=2.26 ps=2.26
xa.xlp.x2.xmp1 0 0 0 0 sky130_fd_pr__pfet_01v8 w=1 l=0.15 ad=0.29 as=0.29 pd=2.58 ps=2.58
xa.xlp.x2.xmp2 0 0 0 0 sky130_fd_pr__pfet_01v8 w=1 l=0.15 ad=0.29 as=0.29 pd=2.58 ps=2.58
xa.xlp.x2.xmn1 0 0 0 0 sky130_fd_pr__nfet_01v8 w=0.84 l=0.15 ad=0.2436 as=0.2436 pd=2.26 ps=2.26
xa.xlp.x2.xmn2 0 0 0 0 sky130_fd_pr__nfet_01v8 w=0.84 l=0.15 ad=0.2436 as=0.2436 pd=2.26 ps=2.26
xa.xip1.xmp 0 0 0 0 sky130_fd_pr__pfet_01v8 w=1 l=0.15 ad=0.29 as=0.29 pd=2.58 ps=2.58
xa.xip1.xmn 0 0 0 0 sky130_fd_pr__nfet_01v8 w=0.42 l=0.15 ad=0.1218 as=0.1218 pd=1.42 ps=1.42
xa.xip2.xmp 0 0 0 0 sky130_fd_pr__pfet_01v8 w=1 l=0.15 ad=0.29 as=0.29 pd=2.58 ps=2.58
xa.xip2.xmn 0 0 0 0 sky130_fd_pr__nfet_01v8 w=0.42 l=0.15 ad=0.1218 as=0.1218 pd=1.42 ps=1.42
xa.xmm1n 0 0 0 0 sky130_fd_pr__nfet_01v8 w=1 l=0.15 ad=0.29 as=0.29 pd=2.58 ps=2.58
xa.xmm1p 0 0 0 0 sky130_fd_pr__pfet_01v8 w=2 l=0.15 ad=0.58 as=0.58 pd=4.58 ps=4.58
xa.xmm2n 0 0 0 0 sky130_fd_pr__nfet_01v8 w=1 l=0.15 ad=0.29 as=0.29 pd=2.58 ps=2.58
xa.xmm2p 0 0 0 0 sky130_fd_pr__pfet_01v8 w=2 l=0.15 ad=0.58 as=0.58 pd=4.58 ps=4.58
vinitb1 vinitb1 0 0.3895
vksb1 ksb1 0 pulse(0 1 1.0 1n 1n 1.9999e-05 2)
vkrb1 krb1 0 pulse(1 0 1.0 1n 1n 0.000121 2)
vkpb1 kpb1 0 pulse(0 1 1.0 1n 1n 0.00012 2)
vtsb1 tsb1 0 dc 1.0
vampb1 ampb1 0 dc 1
vinitb2 vinitb2 0 0.3895
vksb2 ksb2 0 pulse(0 1 1.0 1n 1n 1.9999e-05 2)
vkrb2 krb2 0 pulse(1 0 1.0 1n 1n 0.000121 2)
vkpb2 kpb2 0 pulse(0 1 1.0 1n 1n 0.00012 2)
vtsb2 tsb2 0 dc 1.0
vampb2 ampb2 0 dc 1
b.xb.x1.bip vdd xb.x1.gm i = {ioff} + v(ksb1) * (v(ampb1)*{ipk}*exp(-(time - v(tsb1))*{at}) - {ioff})
b.xb.x1.bsen xb.x1.sen0 0 v = 1.8*v(ksb1)
b.xb.x1.brst xb.x1.rst0 0 v = 1.8*v(krb1)
b.xb.x1.bpreb xb.x1.preb0 0 v = 1.8*v(kpb1)
r.xb.x1.rsen xb.x1.sen0 xb.x1.sen 10k noisy=0
c.xb.x1.csen xb.x1.sen 0 20f
r.xb.x1.rrst xb.x1.rst0 xb.x1.rst 10k noisy=0
c.xb.x1.crst xb.x1.rst 0 20f
r.xb.x1.rpreb xb.x1.preb0 xb.x1.preb 10k noisy=0
c.xb.x1.cpreb xb.x1.preb 0 20f
i.xb.x1.ibs xb.x1.ibs 0 10u
i.xb.x1.ibo xb.x1.ibo 0 10u
xb.x1.xmin xb.x1.gm xb.x1.gm vcm 0 sky130_fd_pr__nfet_01v8 w={wg} l={lg} ad=7.25 as=7.25 pd=51.45 ps=51.45
xb.x1.xmout xb.x1.dq xb.x1.gm xb.vmem1 0 sky130_fd_pr__nfet_01v8 w={wg} l={lg} ad=7.25 as=7.25 pd=51.45 ps=51.45
xb.x1.xnad.xmp1 xb.x1.admb xb.x1.sen vdd vdd sky130_fd_pr__pfet_01v8 w=1 l=0.15 ad=0.29 as=0.29 pd=2.58 ps=2.58
xb.x1.xnad.xmp2 xb.x1.admb xb.pb vdd vdd sky130_fd_pr__pfet_01v8 w=1 l=0.15 ad=0.29 as=0.29 pd=2.58 ps=2.58
xb.x1.xnad.xmn1 xb.x1.admb xb.x1.sen xb.x1.xnad.n1 0 sky130_fd_pr__nfet_01v8 w=0.84 l=0.15 ad=0.2436 as=0.2436 pd=2.26 ps=2.26
xb.x1.xnad.xmn2 xb.x1.xnad.n1 xb.pb 0 0 sky130_fd_pr__nfet_01v8 w=0.84 l=0.15 ad=0.2436 as=0.2436 pd=2.26 ps=2.26
xb.x1.xiad.xmp xb.x1.adm xb.x1.admb vdd vdd sky130_fd_pr__pfet_01v8 w=1 l=0.15 ad=0.29 as=0.29 pd=2.58 ps=2.58
xb.x1.xiad.xmn xb.x1.adm xb.x1.admb 0 0 sky130_fd_pr__nfet_01v8 w=0.42 l=0.15 ad=0.1218 as=0.1218 pd=1.42 ps=1.42
xb.x1.xms1 xb.x1.dq xb.x1.adm xb.vq 0 sky130_fd_pr__nfet_01v8 w=1 l=0.15 ad=0.29 as=0.29 pd=2.58 ps=2.58
xb.x1.xms2 xb.x1.dq xb.x1.admb vr0 0 sky130_fd_pr__nfet_01v8 w=1 l=0.15 ad=0.29 as=0.29 pd=2.58 ps=2.58
c.xb.x1.cs xb.x1.vs 0 {cs0}
xb.x1.xmpre xb.x1.vs xb.x1.preb vpre vdd sky130_fd_pr__pfet_01v8 w=2 l=0.5 ad=0.58 as=0.58 pd=4.58 ps=4.58
i.xb.x1.idis vdd xb.x1.vgd {idis}
xb.x1.xmbd xb.x1.vgd xb.x1.vgd vcm 0 sky130_fd_pr__nfet_01v8 w=0.42 l=8 ad=0.1218 as=0.1218 pd=1.42 ps=1.42
xb.x1.xmdis xb.x1.vs xb.x1.vgd xb.x1.x 0 sky130_fd_pr__nfet_01v8 w=0.42 l=8 ad=0.1218 as=0.1218 pd=1.42 ps=1.42
xb.x1.xmsi xb.x1.x xb.x1.si xb.x1.sum 0 sky130_fd_pr__nfet_01v8 w=1 l=0.15 ad=0.29 as=0.29 pd=2.58 ps=2.58
xb.x1.xmsd xb.x1.x xb.x1.sd vcm 0 sky130_fd_pr__nfet_01v8 w=1 l=0.15 ad=0.29 as=0.29 pd=2.58 ps=2.58
xb.x1.xop.xmb xb.x1.ibo xb.x1.ibo vdd vdd sky130_fd_pr__pfet_01v8 w=8 l=2 ad=2.32 as=2.32 pd=16.58 ps=16.58
xb.x1.xop.xmt xb.x1.xop.tail xb.x1.ibo vdd vdd sky130_fd_pr__pfet_01v8 w=8 l=2 ad=2.32 as=2.32 pd=16.58 ps=16.58
xb.x1.xop.xm1 xb.x1.xop.o1m xb.x1.sum xb.x1.xop.tail vdd sky130_fd_pr__pfet_01v8_lvt w=16 l=1 ad=3.48 as=3.48 pd=24.87 ps=24.87
xb.x1.xop.xm2 xb.x1.xop.o1 xb.x1.vcmn xb.x1.xop.tail vdd sky130_fd_pr__pfet_01v8_lvt w=16 l=1 ad=3.48 as=3.48 pd=24.87 ps=24.87
xb.x1.xop.xm3 xb.x1.xop.o1m xb.x1.xop.o1m 0 0 sky130_fd_pr__nfet_01v8 w=4 l=2 ad=1.16 as=1.16 pd=8.58 ps=8.58
xb.x1.xop.xm4 xb.x1.xop.o1 xb.x1.xop.o1m 0 0 sky130_fd_pr__nfet_01v8 w=4 l=2 ad=1.16 as=1.16 pd=8.58 ps=8.58
xb.x1.xop.xm5 xb.vmem1 xb.x1.xop.o1 0 0 sky130_fd_pr__nfet_01v8 w=16 l=1 ad=3.48 as=3.48 pd=24.87 ps=24.87
xb.x1.xop.xm6 xb.vmem1 xb.x1.ibo vdd vdd sky130_fd_pr__pfet_01v8 w=32 l=2 ad=5.8 as=5.8 pd=41.45 ps=41.45
r.xb.x1.xop.rz xb.x1.xop.o1 xb.x1.xop.oz 4k
c.xb.x1.xop.cc xb.x1.xop.oz xb.vmem1 1.5p
b.xb.x1.bvcmn xb.x1.vcmn0 0 v = v(vcm) + v(xb.x1.nzo)
r.xb.x1.rvcmn xb.x1.vcmn0 xb.x1.vcmn 1k noisy=0
c.xb.x1.cvcmn xb.x1.vcmn 0 20f
c.xb.x1.cf xb.x1.sum xb.vmem1 {cf0}
b.xb.x1.bleak xb.x1.sum 0 i = v(xb.x1.sum)*v(gl)
b.xb.x1.bdrv xb.x1.drv 0 v = min(1.8, max(0, v(vcm) + 10*(v(xb.vmem1) - v(vinitb1))))
v.xb.x1.vrsti xb.x1.rsti0 0 pwl(0 1.8 2.1u 1.8 2.101u 0)
r.xb.x1.rrsti xb.x1.rsti0 xb.x1.rsti 10k noisy=0
c.xb.x1.crsti xb.x1.rsti 0 20f
r.holdb1 xb.x1.sum xb.x1.drv 1e14 noisy=0
xb.x1.xcmps.xmb xb.x1.ibs xb.x1.ibs vdd vdd sky130_fd_pr__pfet_01v8 w=8 l=2 ad=2.32 as=2.32 pd=16.58 ps=16.58
xb.x1.xcmps.xmt xb.x1.xcmps.tail xb.x1.ibs vdd vdd sky130_fd_pr__pfet_01v8 w=16 l=2 ad=3.48 as=3.48 pd=24.87 ps=24.87
xb.x1.xcmps.xm1 xb.x1.xcmps.o1m xb.x1.vrefsn xb.x1.xcmps.tail vdd sky130_fd_pr__pfet_01v8_lvt w={(4)} l={(1)} ad=1.16 as=1.16 pd=8.58 ps=8.58
xb.x1.xcmps.xm2 xb.x1.xcmps.o1 xb.x1.vs xb.x1.xcmps.tail vdd sky130_fd_pr__pfet_01v8_lvt w={(4)} l={(1)} ad=1.16 as=1.16 pd=8.58 ps=8.58
xb.x1.xcmps.xm3 xb.x1.xcmps.o1m xb.x1.xcmps.o1m 0 0 sky130_fd_pr__nfet_01v8 w=2 l=1 ad=0.58 as=0.58 pd=4.58 ps=4.58
xb.x1.xcmps.xm4 xb.x1.xcmps.o1 xb.x1.xcmps.o1m 0 0 sky130_fd_pr__nfet_01v8 w=2 l=1 ad=0.58 as=0.58 pd=4.58 ps=4.58
xb.x1.xcmps.xm5 xb.x1.xcmps.o2 xb.x1.xcmps.o1 0 0 sky130_fd_pr__nfet_01v8 w=2 l=0.5 ad=0.58 as=0.58 pd=4.58 ps=4.58
xb.x1.xcmps.xm6 xb.x1.xcmps.o2 xb.x1.ibs vdd vdd sky130_fd_pr__pfet_01v8 w=16 l=2 ad=3.48 as=3.48 pd=24.87 ps=24.87
xb.x1.xcmps.xi1.xmp xb.x1.xcmps.o3 xb.x1.xcmps.o2 vdd vdd sky130_fd_pr__pfet_01v8 w=1 l=0.15 ad=0.29 as=0.29 pd=2.58 ps=2.58
xb.x1.xcmps.xi1.xmn xb.x1.xcmps.o3 xb.x1.xcmps.o2 0 0 sky130_fd_pr__nfet_01v8 w=0.42 l=0.15 ad=0.1218 as=0.1218 pd=1.42 ps=1.42
xb.x1.xcmps.xi2.xmp xb.x1.cmps xb.x1.xcmps.o3 vdd vdd sky130_fd_pr__pfet_01v8 w=1 l=0.15 ad=0.29 as=0.29 pd=2.58 ps=2.58
xb.x1.xcmps.xi2.xmn xb.x1.cmps xb.x1.xcmps.o3 0 0 sky130_fd_pr__nfet_01v8 w=0.42 l=0.15 ad=0.1218 as=0.1218 pd=1.42 ps=1.42
b.xb.x1.bvrs xb.x1.vrefsn0 0 v = v(xb.x1.vrefs) + v(xb.x1.nzc)
r.xb.x1.rvrs xb.x1.vrefsn0 xb.x1.vrefsn 1k noisy=0
c.xb.x1.cvrs xb.x1.vrefsn 0 20f
xb.x1.xmr1n xb.x1.vrefs xb.x1.adb vhi 0 sky130_fd_pr__nfet_01v8 w=1 l=0.15 ad=0.29 as=0.29 pd=2.58 ps=2.58
xb.x1.xmr1p xb.x1.vrefs xb.x1.ad vhi vdd sky130_fd_pr__pfet_01v8 w=2 l=0.15 ad=0.58 as=0.58 pd=4.58 ps=4.58
xb.x1.xmr2n xb.x1.vrefs xb.x1.ad vlo 0 sky130_fd_pr__nfet_01v8 w=1 l=0.15 ad=0.29 as=0.29 pd=2.58 ps=2.58
xb.x1.xmr2p xb.x1.vrefs xb.x1.adb vlo vdd sky130_fd_pr__pfet_01v8 w=2 l=0.15 ad=0.58 as=0.58 pd=4.58 ps=4.58
v.xb.x1.vnzc xb.x1.nzc 0 dc 0
r.xb.x1.rnzc xb.x1.nzc 0 1k noisy=0
v.xb.x1.vnzo xb.x1.nzo 0 dc 0
r.xb.x1.rnzo xb.x1.nzo 0 1k noisy=0
v.xb.x1.vnzi xb.x1.nzi 0 dc 0
r.xb.x1.rnzi xb.x1.nzi 0 1k noisy=0
g.xb.x1.gnm xb.x1.dq xb.vmem1 xb.x1.nzi 0 1
xb.x1.xien.xmp xb.x1.en xb.x1.rst vdd vdd sky130_fd_pr__pfet_01v8 w=1 l=0.15 ad=0.29 as=0.29 pd=2.58 ps=2.58
xb.x1.xien.xmn xb.x1.en xb.x1.rst 0 0 sky130_fd_pr__nfet_01v8 w=0.42 l=0.15 ad=0.1218 as=0.1218 pd=1.42 ps=1.42
xb.x1.xicb.xmp xb.x1.cmpb xb.x1.cmps vdd vdd sky130_fd_pr__pfet_01v8 w=1 l=0.15 ad=0.29 as=0.29 pd=2.58 ps=2.58
xb.x1.xicb.xmn xb.x1.cmpb xb.x1.cmps 0 0 sky130_fd_pr__nfet_01v8 w=0.42 l=0.15 ad=0.1218 as=0.1218 pd=1.42 ps=1.42
xb.x1.xnsa.xmp1 xb.x1.sba xb.x1.cmpb vdd vdd sky130_fd_pr__pfet_01v8 w=1 l=0.15 ad=0.29 as=0.29 pd=2.58 ps=2.58
xb.x1.xnsa.xmp2 xb.x1.sba xb.x1.en vdd vdd sky130_fd_pr__pfet_01v8 w=1 l=0.15 ad=0.29 as=0.29 pd=2.58 ps=2.58
xb.x1.xnsa.xmn1 xb.x1.sba xb.x1.cmpb xb.x1.xnsa.n1 0 sky130_fd_pr__nfet_01v8 w=0.84 l=0.15 ad=0.2436 as=0.2436 pd=2.26 ps=2.26
xb.x1.xnsa.xmn2 xb.x1.xnsa.n1 xb.x1.en 0 0 sky130_fd_pr__nfet_01v8 w=0.84 l=0.15 ad=0.2436 as=0.2436 pd=2.26 ps=2.26
xb.x1.xla.x1.xmp1 xb.x1.a xb.x1.sba vdd vdd sky130_fd_pr__pfet_01v8 w=1 l=0.15 ad=0.29 as=0.29 pd=2.58 ps=2.58
xb.x1.xla.x1.xmp2 xb.x1.a xb.x1.ab vdd vdd sky130_fd_pr__pfet_01v8 w=1 l=0.15 ad=0.29 as=0.29 pd=2.58 ps=2.58
xb.x1.xla.x1.xmn1 xb.x1.a xb.x1.sba xb.x1.xla.x1.n1 0 sky130_fd_pr__nfet_01v8 w=0.84 l=0.15 ad=0.2436 as=0.2436 pd=2.26 ps=2.26
xb.x1.xla.x1.xmn2 xb.x1.xla.x1.n1 xb.x1.ab 0 0 sky130_fd_pr__nfet_01v8 w=0.84 l=0.15 ad=0.2436 as=0.2436 pd=2.26 ps=2.26
xb.x1.xla.x2.xmp1 xb.x1.ab xb.x1.en vdd vdd sky130_fd_pr__pfet_01v8 w=1 l=0.15 ad=0.29 as=0.29 pd=2.58 ps=2.58
xb.x1.xla.x2.xmp2 xb.x1.ab xb.x1.a vdd vdd sky130_fd_pr__pfet_01v8 w=1 l=0.15 ad=0.29 as=0.29 pd=2.58 ps=2.58
xb.x1.xla.x2.xmn1 xb.x1.ab xb.x1.en xb.x1.xla.x2.n1 0 sky130_fd_pr__nfet_01v8 w=0.84 l=0.15 ad=0.2436 as=0.2436 pd=2.26 ps=2.26
xb.x1.xla.x2.xmn2 xb.x1.xla.x2.n1 xb.x1.a 0 0 sky130_fd_pr__nfet_01v8 w=0.84 l=0.15 ad=0.2436 as=0.2436 pd=2.26 ps=2.26
r.xb.x1.rda xb.x1.a xb.x1.ad1 100k
c.xb.x1.cda xb.x1.ad1 0 200f
xb.x1.xia1.xmp xb.x1.adb xb.x1.ad1 vdd vdd sky130_fd_pr__pfet_01v8 w=1 l=0.15 ad=0.29 as=0.29 pd=2.58 ps=2.58
xb.x1.xia1.xmn xb.x1.adb xb.x1.ad1 0 0 sky130_fd_pr__nfet_01v8 w=0.42 l=0.15 ad=0.1218 as=0.1218 pd=1.42 ps=1.42
xb.x1.xia2.xmp xb.x1.ad xb.x1.adb vdd vdd sky130_fd_pr__pfet_01v8 w=1 l=0.15 ad=0.29 as=0.29 pd=2.58 ps=2.58
xb.x1.xia2.xmn xb.x1.ad xb.x1.adb 0 0 sky130_fd_pr__nfet_01v8 w=0.42 l=0.15 ad=0.1218 as=0.1218 pd=1.42 ps=1.42
xb.x1.xnsc.xmp1 xb.x1.sbc0 xb.x1.ad vdd vdd sky130_fd_pr__pfet_01v8 w=1 l=0.15 ad=0.29 as=0.29 pd=2.58 ps=2.58
xb.x1.xnsc.xmp2 xb.x1.sbc0 xb.x1.cmps vdd vdd sky130_fd_pr__pfet_01v8 w=1 l=0.15 ad=0.29 as=0.29 pd=2.58 ps=2.58
xb.x1.xnsc.xmn1 xb.x1.sbc0 xb.x1.ad xb.x1.xnsc.n1 0 sky130_fd_pr__nfet_01v8 w=0.84 l=0.15 ad=0.2436 as=0.2436 pd=2.26 ps=2.26
xb.x1.xnsc.xmn2 xb.x1.xnsc.n1 xb.x1.cmps 0 0 sky130_fd_pr__nfet_01v8 w=0.84 l=0.15 ad=0.2436 as=0.2436 pd=2.26 ps=2.26
xb.x1.xlc.x1.xmp1 xb.x1.c xb.x1.sbc0 vdd vdd sky130_fd_pr__pfet_01v8 w=1 l=0.15 ad=0.29 as=0.29 pd=2.58 ps=2.58
xb.x1.xlc.x1.xmp2 xb.x1.c xb.x1.cbar vdd vdd sky130_fd_pr__pfet_01v8 w=1 l=0.15 ad=0.29 as=0.29 pd=2.58 ps=2.58
xb.x1.xlc.x1.xmn1 xb.x1.c xb.x1.sbc0 xb.x1.xlc.x1.n1 0 sky130_fd_pr__nfet_01v8 w=0.84 l=0.15 ad=0.2436 as=0.2436 pd=2.26 ps=2.26
xb.x1.xlc.x1.xmn2 xb.x1.xlc.x1.n1 xb.x1.cbar 0 0 sky130_fd_pr__nfet_01v8 w=0.84 l=0.15 ad=0.2436 as=0.2436 pd=2.26 ps=2.26
xb.x1.xlc.x2.xmp1 xb.x1.cbar xb.x1.en vdd vdd sky130_fd_pr__pfet_01v8 w=1 l=0.15 ad=0.29 as=0.29 pd=2.58 ps=2.58
xb.x1.xlc.x2.xmp2 xb.x1.cbar xb.x1.c vdd vdd sky130_fd_pr__pfet_01v8 w=1 l=0.15 ad=0.29 as=0.29 pd=2.58 ps=2.58
xb.x1.xlc.x2.xmn1 xb.x1.cbar xb.x1.en xb.x1.xlc.x2.n1 0 sky130_fd_pr__nfet_01v8 w=0.84 l=0.15 ad=0.2436 as=0.2436 pd=2.26 ps=2.26
xb.x1.xlc.x2.xmn2 xb.x1.xlc.x2.n1 xb.x1.c 0 0 sky130_fd_pr__nfet_01v8 w=0.84 l=0.15 ad=0.2436 as=0.2436 pd=2.26 ps=2.26
r.xb.x1.rdl xb.x1.c xb.x1.cd1 100k
c.xb.x1.cdl xb.x1.cd1 0 200f
xb.x1.xid1.xmp xb.x1.cd2 xb.x1.cd1 vdd vdd sky130_fd_pr__pfet_01v8 w=1 l=0.15 ad=0.29 as=0.29 pd=2.58 ps=2.58
xb.x1.xid1.xmn xb.x1.cd2 xb.x1.cd1 0 0 sky130_fd_pr__nfet_01v8 w=0.42 l=0.15 ad=0.1218 as=0.1218 pd=1.42 ps=1.42
xb.x1.xid2.xmp xb.x1.cdel xb.x1.cd2 vdd vdd sky130_fd_pr__pfet_01v8 w=1 l=0.15 ad=0.29 as=0.29 pd=2.58 ps=2.58
xb.x1.xid2.xmn xb.x1.cdel xb.x1.cd2 0 0 sky130_fd_pr__nfet_01v8 w=0.42 l=0.15 ad=0.1218 as=0.1218 pd=1.42 ps=1.42
xb.x1.xnsb.xmp1 xb.x1.sbb xb.x1.cdel vdd vdd sky130_fd_pr__pfet_01v8 w=1 l=0.15 ad=0.29 as=0.29 pd=2.58 ps=2.58
xb.x1.xnsb.xmp2 xb.x1.sbb xb.x1.cmpb vdd vdd sky130_fd_pr__pfet_01v8 w=1 l=0.15 ad=0.29 as=0.29 pd=2.58 ps=2.58
xb.x1.xnsb.xmn1 xb.x1.sbb xb.x1.cdel xb.x1.xnsb.n1 0 sky130_fd_pr__nfet_01v8 w=0.84 l=0.15 ad=0.2436 as=0.2436 pd=2.26 ps=2.26
xb.x1.xnsb.xmn2 xb.x1.xnsb.n1 xb.x1.cmpb 0 0 sky130_fd_pr__nfet_01v8 w=0.84 l=0.15 ad=0.2436 as=0.2436 pd=2.26 ps=2.26
xb.x1.xlb.x1.xmp1 xb.x1.b xb.x1.sbb vdd vdd sky130_fd_pr__pfet_01v8 w=1 l=0.15 ad=0.29 as=0.29 pd=2.58 ps=2.58
xb.x1.xlb.x1.xmp2 xb.x1.b xb.x1.bb vdd vdd sky130_fd_pr__pfet_01v8 w=1 l=0.15 ad=0.29 as=0.29 pd=2.58 ps=2.58
xb.x1.xlb.x1.xmn1 xb.x1.b xb.x1.sbb xb.x1.xlb.x1.n1 0 sky130_fd_pr__nfet_01v8 w=0.84 l=0.15 ad=0.2436 as=0.2436 pd=2.26 ps=2.26
xb.x1.xlb.x1.xmn2 xb.x1.xlb.x1.n1 xb.x1.bb 0 0 sky130_fd_pr__nfet_01v8 w=0.84 l=0.15 ad=0.2436 as=0.2436 pd=2.26 ps=2.26
xb.x1.xlb.x2.xmp1 xb.x1.bb xb.x1.en vdd vdd sky130_fd_pr__pfet_01v8 w=1 l=0.15 ad=0.29 as=0.29 pd=2.58 ps=2.58
xb.x1.xlb.x2.xmp2 xb.x1.bb xb.x1.b vdd vdd sky130_fd_pr__pfet_01v8 w=1 l=0.15 ad=0.29 as=0.29 pd=2.58 ps=2.58
xb.x1.xlb.x2.xmn1 xb.x1.bb xb.x1.en xb.x1.xlb.x2.n1 0 sky130_fd_pr__nfet_01v8 w=0.84 l=0.15 ad=0.2436 as=0.2436 pd=2.26 ps=2.26
xb.x1.xlb.x2.xmn2 xb.x1.xlb.x2.n1 xb.x1.b 0 0 sky130_fd_pr__nfet_01v8 w=0.84 l=0.15 ad=0.2436 as=0.2436 pd=2.26 ps=2.26
xb.x1.xnsi.xmp1 xb.x1.sib xb.x1.a vdd vdd sky130_fd_pr__pfet_01v8 w=1 l=0.15 ad=0.29 as=0.29 pd=2.58 ps=2.58
xb.x1.xnsi.xmp2 xb.x1.sib xb.x1.bb vdd vdd sky130_fd_pr__pfet_01v8 w=1 l=0.15 ad=0.29 as=0.29 pd=2.58 ps=2.58
xb.x1.xnsi.xmp3 xb.x1.sib xb.pb vdd vdd sky130_fd_pr__pfet_01v8 w=1 l=0.15 ad=0.29 as=0.29 pd=2.58 ps=2.58
xb.x1.xnsi.xmn1 xb.x1.sib xb.x1.a xb.x1.xnsi.n1 0 sky130_fd_pr__nfet_01v8 w=1.26 l=0.15 ad=0.3654 as=0.3654 pd=3.1 ps=3.1
xb.x1.xnsi.xmn2 xb.x1.xnsi.n1 xb.x1.bb xb.x1.xnsi.n2 0 sky130_fd_pr__nfet_01v8 w=1.26 l=0.15 ad=0.3654 as=0.3654 pd=3.1 ps=3.1
xb.x1.xnsi.xmn3 xb.x1.xnsi.n2 xb.pb 0 0 sky130_fd_pr__nfet_01v8 w=1.26 l=0.15 ad=0.3654 as=0.3654 pd=3.1 ps=3.1
xb.x1.xisi.xmp xb.x1.si xb.x1.sib vdd vdd sky130_fd_pr__pfet_01v8 w=1 l=0.15 ad=0.29 as=0.29 pd=2.58 ps=2.58
xb.x1.xisi.xmn xb.x1.si xb.x1.sib 0 0 sky130_fd_pr__nfet_01v8 w=0.42 l=0.15 ad=0.1218 as=0.1218 pd=1.42 ps=1.42
xb.x1.xisd.xmp xb.x1.sd xb.x1.si vdd vdd sky130_fd_pr__pfet_01v8 w=1 l=0.15 ad=0.29 as=0.29 pd=2.58 ps=2.58
xb.x1.xisd.xmn xb.x1.sd xb.x1.si 0 0 sky130_fd_pr__nfet_01v8 w=0.42 l=0.15 ad=0.1218 as=0.1218 pd=1.42 ps=1.42
b.xb.x2.bip vdd xb.x2.gm i = {ioff} + v(ksb2) * (v(ampb2)*{ipk}*exp(-(time - v(tsb2))*{at}) - {ioff})
b.xb.x2.bsen xb.x2.sen0 0 v = 1.8*v(ksb2)
b.xb.x2.brst xb.x2.rst0 0 v = 1.8*v(krb2)
b.xb.x2.bpreb xb.x2.preb0 0 v = 1.8*v(kpb2)
r.xb.x2.rsen xb.x2.sen0 xb.x2.sen 10k noisy=0
c.xb.x2.csen xb.x2.sen 0 20f
r.xb.x2.rrst xb.x2.rst0 xb.x2.rst 10k noisy=0
c.xb.x2.crst xb.x2.rst 0 20f
r.xb.x2.rpreb xb.x2.preb0 xb.x2.preb 10k noisy=0
c.xb.x2.cpreb xb.x2.preb 0 20f
i.xb.x2.ibs xb.x2.ibs 0 10u
i.xb.x2.ibo xb.x2.ibo 0 10u
xb.x2.xmin xb.x2.gm xb.x2.gm vcm 0 sky130_fd_pr__nfet_01v8 w={wg} l={lg} ad=7.25 as=7.25 pd=51.45 ps=51.45
xb.x2.xmout xb.x2.dq xb.x2.gm xb.vmem2 0 sky130_fd_pr__nfet_01v8 w={wg} l={lg} ad=7.25 as=7.25 pd=51.45 ps=51.45
xb.x2.xnad.xmp1 xb.x2.admb xb.x2.sen vdd vdd sky130_fd_pr__pfet_01v8 w=1 l=0.15 ad=0.29 as=0.29 pd=2.58 ps=2.58
xb.x2.xnad.xmp2 xb.x2.admb xb.pb vdd vdd sky130_fd_pr__pfet_01v8 w=1 l=0.15 ad=0.29 as=0.29 pd=2.58 ps=2.58
xb.x2.xnad.xmn1 xb.x2.admb xb.x2.sen xb.x2.xnad.n1 0 sky130_fd_pr__nfet_01v8 w=0.84 l=0.15 ad=0.2436 as=0.2436 pd=2.26 ps=2.26
xb.x2.xnad.xmn2 xb.x2.xnad.n1 xb.pb 0 0 sky130_fd_pr__nfet_01v8 w=0.84 l=0.15 ad=0.2436 as=0.2436 pd=2.26 ps=2.26
xb.x2.xiad.xmp xb.x2.adm xb.x2.admb vdd vdd sky130_fd_pr__pfet_01v8 w=1 l=0.15 ad=0.29 as=0.29 pd=2.58 ps=2.58
xb.x2.xiad.xmn xb.x2.adm xb.x2.admb 0 0 sky130_fd_pr__nfet_01v8 w=0.42 l=0.15 ad=0.1218 as=0.1218 pd=1.42 ps=1.42
xb.x2.xms1 xb.x2.dq xb.x2.adm xb.vq 0 sky130_fd_pr__nfet_01v8 w=1 l=0.15 ad=0.29 as=0.29 pd=2.58 ps=2.58
xb.x2.xms2 xb.x2.dq xb.x2.admb vr0 0 sky130_fd_pr__nfet_01v8 w=1 l=0.15 ad=0.29 as=0.29 pd=2.58 ps=2.58
c.xb.x2.cs xb.x2.vs 0 {cs0}
xb.x2.xmpre xb.x2.vs xb.x2.preb vpre vdd sky130_fd_pr__pfet_01v8 w=2 l=0.5 ad=0.58 as=0.58 pd=4.58 ps=4.58
i.xb.x2.idis vdd xb.x2.vgd {idis}
xb.x2.xmbd xb.x2.vgd xb.x2.vgd vcm 0 sky130_fd_pr__nfet_01v8 w=0.42 l=8 ad=0.1218 as=0.1218 pd=1.42 ps=1.42
xb.x2.xmdis xb.x2.vs xb.x2.vgd xb.x2.x 0 sky130_fd_pr__nfet_01v8 w=0.42 l=8 ad=0.1218 as=0.1218 pd=1.42 ps=1.42
xb.x2.xmsi xb.x2.x xb.x2.si xb.x2.sum 0 sky130_fd_pr__nfet_01v8 w=1 l=0.15 ad=0.29 as=0.29 pd=2.58 ps=2.58
xb.x2.xmsd xb.x2.x xb.x2.sd vcm 0 sky130_fd_pr__nfet_01v8 w=1 l=0.15 ad=0.29 as=0.29 pd=2.58 ps=2.58
xb.x2.xop.xmb xb.x2.ibo xb.x2.ibo vdd vdd sky130_fd_pr__pfet_01v8 w=8 l=2 ad=2.32 as=2.32 pd=16.58 ps=16.58
xb.x2.xop.xmt xb.x2.xop.tail xb.x2.ibo vdd vdd sky130_fd_pr__pfet_01v8 w=8 l=2 ad=2.32 as=2.32 pd=16.58 ps=16.58
xb.x2.xop.xm1 xb.x2.xop.o1m xb.x2.sum xb.x2.xop.tail vdd sky130_fd_pr__pfet_01v8_lvt w=16 l=1 ad=3.48 as=3.48 pd=24.87 ps=24.87
xb.x2.xop.xm2 xb.x2.xop.o1 xb.x2.vcmn xb.x2.xop.tail vdd sky130_fd_pr__pfet_01v8_lvt w=16 l=1 ad=3.48 as=3.48 pd=24.87 ps=24.87
xb.x2.xop.xm3 xb.x2.xop.o1m xb.x2.xop.o1m 0 0 sky130_fd_pr__nfet_01v8 w=4 l=2 ad=1.16 as=1.16 pd=8.58 ps=8.58
xb.x2.xop.xm4 xb.x2.xop.o1 xb.x2.xop.o1m 0 0 sky130_fd_pr__nfet_01v8 w=4 l=2 ad=1.16 as=1.16 pd=8.58 ps=8.58
xb.x2.xop.xm5 xb.vmem2 xb.x2.xop.o1 0 0 sky130_fd_pr__nfet_01v8 w=16 l=1 ad=3.48 as=3.48 pd=24.87 ps=24.87
xb.x2.xop.xm6 xb.vmem2 xb.x2.ibo vdd vdd sky130_fd_pr__pfet_01v8 w=32 l=2 ad=5.8 as=5.8 pd=41.45 ps=41.45
r.xb.x2.xop.rz xb.x2.xop.o1 xb.x2.xop.oz 4k
c.xb.x2.xop.cc xb.x2.xop.oz xb.vmem2 1.5p
b.xb.x2.bvcmn xb.x2.vcmn0 0 v = v(vcm) + v(xb.x2.nzo)
r.xb.x2.rvcmn xb.x2.vcmn0 xb.x2.vcmn 1k noisy=0
c.xb.x2.cvcmn xb.x2.vcmn 0 20f
c.xb.x2.cf xb.x2.sum xb.vmem2 {cf0}
b.xb.x2.bleak xb.x2.sum 0 i = v(xb.x2.sum)*v(gl)
b.xb.x2.bdrv xb.x2.drv 0 v = min(1.8, max(0, v(vcm) + 10*(v(xb.vmem2) - v(vinitb2))))
v.xb.x2.vrsti xb.x2.rsti0 0 pwl(0 1.8 2.1u 1.8 2.101u 0)
r.xb.x2.rrsti xb.x2.rsti0 xb.x2.rsti 10k noisy=0
c.xb.x2.crsti xb.x2.rsti 0 20f
r.holdb2 xb.x2.sum xb.x2.drv 1e14 noisy=0
xb.x2.xcmps.xmb xb.x2.ibs xb.x2.ibs vdd vdd sky130_fd_pr__pfet_01v8 w=8 l=2 ad=2.32 as=2.32 pd=16.58 ps=16.58
xb.x2.xcmps.xmt xb.x2.xcmps.tail xb.x2.ibs vdd vdd sky130_fd_pr__pfet_01v8 w=16 l=2 ad=3.48 as=3.48 pd=24.87 ps=24.87
xb.x2.xcmps.xm1 xb.x2.xcmps.o1m xb.x2.vrefsn xb.x2.xcmps.tail vdd sky130_fd_pr__pfet_01v8_lvt w={(4)} l={(1)} ad=1.16 as=1.16 pd=8.58 ps=8.58
xb.x2.xcmps.xm2 xb.x2.xcmps.o1 xb.x2.vs xb.x2.xcmps.tail vdd sky130_fd_pr__pfet_01v8_lvt w={(4)} l={(1)} ad=1.16 as=1.16 pd=8.58 ps=8.58
xb.x2.xcmps.xm3 xb.x2.xcmps.o1m xb.x2.xcmps.o1m 0 0 sky130_fd_pr__nfet_01v8 w=2 l=1 ad=0.58 as=0.58 pd=4.58 ps=4.58
xb.x2.xcmps.xm4 xb.x2.xcmps.o1 xb.x2.xcmps.o1m 0 0 sky130_fd_pr__nfet_01v8 w=2 l=1 ad=0.58 as=0.58 pd=4.58 ps=4.58
xb.x2.xcmps.xm5 xb.x2.xcmps.o2 xb.x2.xcmps.o1 0 0 sky130_fd_pr__nfet_01v8 w=2 l=0.5 ad=0.58 as=0.58 pd=4.58 ps=4.58
xb.x2.xcmps.xm6 xb.x2.xcmps.o2 xb.x2.ibs vdd vdd sky130_fd_pr__pfet_01v8 w=16 l=2 ad=3.48 as=3.48 pd=24.87 ps=24.87
xb.x2.xcmps.xi1.xmp xb.x2.xcmps.o3 xb.x2.xcmps.o2 vdd vdd sky130_fd_pr__pfet_01v8 w=1 l=0.15 ad=0.29 as=0.29 pd=2.58 ps=2.58
xb.x2.xcmps.xi1.xmn xb.x2.xcmps.o3 xb.x2.xcmps.o2 0 0 sky130_fd_pr__nfet_01v8 w=0.42 l=0.15 ad=0.1218 as=0.1218 pd=1.42 ps=1.42
xb.x2.xcmps.xi2.xmp xb.x2.cmps xb.x2.xcmps.o3 vdd vdd sky130_fd_pr__pfet_01v8 w=1 l=0.15 ad=0.29 as=0.29 pd=2.58 ps=2.58
xb.x2.xcmps.xi2.xmn xb.x2.cmps xb.x2.xcmps.o3 0 0 sky130_fd_pr__nfet_01v8 w=0.42 l=0.15 ad=0.1218 as=0.1218 pd=1.42 ps=1.42
b.xb.x2.bvrs xb.x2.vrefsn0 0 v = v(xb.x2.vrefs) + v(xb.x2.nzc)
r.xb.x2.rvrs xb.x2.vrefsn0 xb.x2.vrefsn 1k noisy=0
c.xb.x2.cvrs xb.x2.vrefsn 0 20f
xb.x2.xmr1n xb.x2.vrefs xb.x2.adb vhi 0 sky130_fd_pr__nfet_01v8 w=1 l=0.15 ad=0.29 as=0.29 pd=2.58 ps=2.58
xb.x2.xmr1p xb.x2.vrefs xb.x2.ad vhi vdd sky130_fd_pr__pfet_01v8 w=2 l=0.15 ad=0.58 as=0.58 pd=4.58 ps=4.58
xb.x2.xmr2n xb.x2.vrefs xb.x2.ad vlo 0 sky130_fd_pr__nfet_01v8 w=1 l=0.15 ad=0.29 as=0.29 pd=2.58 ps=2.58
xb.x2.xmr2p xb.x2.vrefs xb.x2.adb vlo vdd sky130_fd_pr__pfet_01v8 w=2 l=0.15 ad=0.58 as=0.58 pd=4.58 ps=4.58
v.xb.x2.vnzc xb.x2.nzc 0 dc 0
r.xb.x2.rnzc xb.x2.nzc 0 1k noisy=0
v.xb.x2.vnzo xb.x2.nzo 0 dc 0
r.xb.x2.rnzo xb.x2.nzo 0 1k noisy=0
v.xb.x2.vnzi xb.x2.nzi 0 dc 0
r.xb.x2.rnzi xb.x2.nzi 0 1k noisy=0
g.xb.x2.gnm xb.x2.dq xb.vmem2 xb.x2.nzi 0 1
xb.x2.xien.xmp xb.x2.en xb.x2.rst vdd vdd sky130_fd_pr__pfet_01v8 w=1 l=0.15 ad=0.29 as=0.29 pd=2.58 ps=2.58
xb.x2.xien.xmn xb.x2.en xb.x2.rst 0 0 sky130_fd_pr__nfet_01v8 w=0.42 l=0.15 ad=0.1218 as=0.1218 pd=1.42 ps=1.42
xb.x2.xicb.xmp xb.x2.cmpb xb.x2.cmps vdd vdd sky130_fd_pr__pfet_01v8 w=1 l=0.15 ad=0.29 as=0.29 pd=2.58 ps=2.58
xb.x2.xicb.xmn xb.x2.cmpb xb.x2.cmps 0 0 sky130_fd_pr__nfet_01v8 w=0.42 l=0.15 ad=0.1218 as=0.1218 pd=1.42 ps=1.42
xb.x2.xnsa.xmp1 xb.x2.sba xb.x2.cmpb vdd vdd sky130_fd_pr__pfet_01v8 w=1 l=0.15 ad=0.29 as=0.29 pd=2.58 ps=2.58
xb.x2.xnsa.xmp2 xb.x2.sba xb.x2.en vdd vdd sky130_fd_pr__pfet_01v8 w=1 l=0.15 ad=0.29 as=0.29 pd=2.58 ps=2.58
xb.x2.xnsa.xmn1 xb.x2.sba xb.x2.cmpb xb.x2.xnsa.n1 0 sky130_fd_pr__nfet_01v8 w=0.84 l=0.15 ad=0.2436 as=0.2436 pd=2.26 ps=2.26
xb.x2.xnsa.xmn2 xb.x2.xnsa.n1 xb.x2.en 0 0 sky130_fd_pr__nfet_01v8 w=0.84 l=0.15 ad=0.2436 as=0.2436 pd=2.26 ps=2.26
xb.x2.xla.x1.xmp1 xb.x2.a xb.x2.sba vdd vdd sky130_fd_pr__pfet_01v8 w=1 l=0.15 ad=0.29 as=0.29 pd=2.58 ps=2.58
xb.x2.xla.x1.xmp2 xb.x2.a xb.x2.ab vdd vdd sky130_fd_pr__pfet_01v8 w=1 l=0.15 ad=0.29 as=0.29 pd=2.58 ps=2.58
xb.x2.xla.x1.xmn1 xb.x2.a xb.x2.sba xb.x2.xla.x1.n1 0 sky130_fd_pr__nfet_01v8 w=0.84 l=0.15 ad=0.2436 as=0.2436 pd=2.26 ps=2.26
xb.x2.xla.x1.xmn2 xb.x2.xla.x1.n1 xb.x2.ab 0 0 sky130_fd_pr__nfet_01v8 w=0.84 l=0.15 ad=0.2436 as=0.2436 pd=2.26 ps=2.26
xb.x2.xla.x2.xmp1 xb.x2.ab xb.x2.en vdd vdd sky130_fd_pr__pfet_01v8 w=1 l=0.15 ad=0.29 as=0.29 pd=2.58 ps=2.58
xb.x2.xla.x2.xmp2 xb.x2.ab xb.x2.a vdd vdd sky130_fd_pr__pfet_01v8 w=1 l=0.15 ad=0.29 as=0.29 pd=2.58 ps=2.58
xb.x2.xla.x2.xmn1 xb.x2.ab xb.x2.en xb.x2.xla.x2.n1 0 sky130_fd_pr__nfet_01v8 w=0.84 l=0.15 ad=0.2436 as=0.2436 pd=2.26 ps=2.26
xb.x2.xla.x2.xmn2 xb.x2.xla.x2.n1 xb.x2.a 0 0 sky130_fd_pr__nfet_01v8 w=0.84 l=0.15 ad=0.2436 as=0.2436 pd=2.26 ps=2.26
r.xb.x2.rda xb.x2.a xb.x2.ad1 100k
c.xb.x2.cda xb.x2.ad1 0 200f
xb.x2.xia1.xmp xb.x2.adb xb.x2.ad1 vdd vdd sky130_fd_pr__pfet_01v8 w=1 l=0.15 ad=0.29 as=0.29 pd=2.58 ps=2.58
xb.x2.xia1.xmn xb.x2.adb xb.x2.ad1 0 0 sky130_fd_pr__nfet_01v8 w=0.42 l=0.15 ad=0.1218 as=0.1218 pd=1.42 ps=1.42
xb.x2.xia2.xmp xb.x2.ad xb.x2.adb vdd vdd sky130_fd_pr__pfet_01v8 w=1 l=0.15 ad=0.29 as=0.29 pd=2.58 ps=2.58
xb.x2.xia2.xmn xb.x2.ad xb.x2.adb 0 0 sky130_fd_pr__nfet_01v8 w=0.42 l=0.15 ad=0.1218 as=0.1218 pd=1.42 ps=1.42
xb.x2.xnsc.xmp1 xb.x2.sbc0 xb.x2.ad vdd vdd sky130_fd_pr__pfet_01v8 w=1 l=0.15 ad=0.29 as=0.29 pd=2.58 ps=2.58
xb.x2.xnsc.xmp2 xb.x2.sbc0 xb.x2.cmps vdd vdd sky130_fd_pr__pfet_01v8 w=1 l=0.15 ad=0.29 as=0.29 pd=2.58 ps=2.58
xb.x2.xnsc.xmn1 xb.x2.sbc0 xb.x2.ad xb.x2.xnsc.n1 0 sky130_fd_pr__nfet_01v8 w=0.84 l=0.15 ad=0.2436 as=0.2436 pd=2.26 ps=2.26
xb.x2.xnsc.xmn2 xb.x2.xnsc.n1 xb.x2.cmps 0 0 sky130_fd_pr__nfet_01v8 w=0.84 l=0.15 ad=0.2436 as=0.2436 pd=2.26 ps=2.26
xb.x2.xlc.x1.xmp1 xb.x2.c xb.x2.sbc0 vdd vdd sky130_fd_pr__pfet_01v8 w=1 l=0.15 ad=0.29 as=0.29 pd=2.58 ps=2.58
xb.x2.xlc.x1.xmp2 xb.x2.c xb.x2.cbar vdd vdd sky130_fd_pr__pfet_01v8 w=1 l=0.15 ad=0.29 as=0.29 pd=2.58 ps=2.58
xb.x2.xlc.x1.xmn1 xb.x2.c xb.x2.sbc0 xb.x2.xlc.x1.n1 0 sky130_fd_pr__nfet_01v8 w=0.84 l=0.15 ad=0.2436 as=0.2436 pd=2.26 ps=2.26
xb.x2.xlc.x1.xmn2 xb.x2.xlc.x1.n1 xb.x2.cbar 0 0 sky130_fd_pr__nfet_01v8 w=0.84 l=0.15 ad=0.2436 as=0.2436 pd=2.26 ps=2.26
xb.x2.xlc.x2.xmp1 xb.x2.cbar xb.x2.en vdd vdd sky130_fd_pr__pfet_01v8 w=1 l=0.15 ad=0.29 as=0.29 pd=2.58 ps=2.58
xb.x2.xlc.x2.xmp2 xb.x2.cbar xb.x2.c vdd vdd sky130_fd_pr__pfet_01v8 w=1 l=0.15 ad=0.29 as=0.29 pd=2.58 ps=2.58
xb.x2.xlc.x2.xmn1 xb.x2.cbar xb.x2.en xb.x2.xlc.x2.n1 0 sky130_fd_pr__nfet_01v8 w=0.84 l=0.15 ad=0.2436 as=0.2436 pd=2.26 ps=2.26
xb.x2.xlc.x2.xmn2 xb.x2.xlc.x2.n1 xb.x2.c 0 0 sky130_fd_pr__nfet_01v8 w=0.84 l=0.15 ad=0.2436 as=0.2436 pd=2.26 ps=2.26
r.xb.x2.rdl xb.x2.c xb.x2.cd1 100k
c.xb.x2.cdl xb.x2.cd1 0 200f
xb.x2.xid1.xmp xb.x2.cd2 xb.x2.cd1 vdd vdd sky130_fd_pr__pfet_01v8 w=1 l=0.15 ad=0.29 as=0.29 pd=2.58 ps=2.58
xb.x2.xid1.xmn xb.x2.cd2 xb.x2.cd1 0 0 sky130_fd_pr__nfet_01v8 w=0.42 l=0.15 ad=0.1218 as=0.1218 pd=1.42 ps=1.42
xb.x2.xid2.xmp xb.x2.cdel xb.x2.cd2 vdd vdd sky130_fd_pr__pfet_01v8 w=1 l=0.15 ad=0.29 as=0.29 pd=2.58 ps=2.58
xb.x2.xid2.xmn xb.x2.cdel xb.x2.cd2 0 0 sky130_fd_pr__nfet_01v8 w=0.42 l=0.15 ad=0.1218 as=0.1218 pd=1.42 ps=1.42
xb.x2.xnsb.xmp1 xb.x2.sbb xb.x2.cdel vdd vdd sky130_fd_pr__pfet_01v8 w=1 l=0.15 ad=0.29 as=0.29 pd=2.58 ps=2.58
xb.x2.xnsb.xmp2 xb.x2.sbb xb.x2.cmpb vdd vdd sky130_fd_pr__pfet_01v8 w=1 l=0.15 ad=0.29 as=0.29 pd=2.58 ps=2.58
xb.x2.xnsb.xmn1 xb.x2.sbb xb.x2.cdel xb.x2.xnsb.n1 0 sky130_fd_pr__nfet_01v8 w=0.84 l=0.15 ad=0.2436 as=0.2436 pd=2.26 ps=2.26
xb.x2.xnsb.xmn2 xb.x2.xnsb.n1 xb.x2.cmpb 0 0 sky130_fd_pr__nfet_01v8 w=0.84 l=0.15 ad=0.2436 as=0.2436 pd=2.26 ps=2.26
xb.x2.xlb.x1.xmp1 xb.x2.b xb.x2.sbb vdd vdd sky130_fd_pr__pfet_01v8 w=1 l=0.15 ad=0.29 as=0.29 pd=2.58 ps=2.58
xb.x2.xlb.x1.xmp2 xb.x2.b xb.x2.bb vdd vdd sky130_fd_pr__pfet_01v8 w=1 l=0.15 ad=0.29 as=0.29 pd=2.58 ps=2.58
xb.x2.xlb.x1.xmn1 xb.x2.b xb.x2.sbb xb.x2.xlb.x1.n1 0 sky130_fd_pr__nfet_01v8 w=0.84 l=0.15 ad=0.2436 as=0.2436 pd=2.26 ps=2.26
xb.x2.xlb.x1.xmn2 xb.x2.xlb.x1.n1 xb.x2.bb 0 0 sky130_fd_pr__nfet_01v8 w=0.84 l=0.15 ad=0.2436 as=0.2436 pd=2.26 ps=2.26
xb.x2.xlb.x2.xmp1 xb.x2.bb xb.x2.en vdd vdd sky130_fd_pr__pfet_01v8 w=1 l=0.15 ad=0.29 as=0.29 pd=2.58 ps=2.58
xb.x2.xlb.x2.xmp2 xb.x2.bb xb.x2.b vdd vdd sky130_fd_pr__pfet_01v8 w=1 l=0.15 ad=0.29 as=0.29 pd=2.58 ps=2.58
xb.x2.xlb.x2.xmn1 xb.x2.bb xb.x2.en xb.x2.xlb.x2.n1 0 sky130_fd_pr__nfet_01v8 w=0.84 l=0.15 ad=0.2436 as=0.2436 pd=2.26 ps=2.26
xb.x2.xlb.x2.xmn2 xb.x2.xlb.x2.n1 xb.x2.b 0 0 sky130_fd_pr__nfet_01v8 w=0.84 l=0.15 ad=0.2436 as=0.2436 pd=2.26 ps=2.26
xb.x2.xnsi.xmp1 xb.x2.sib xb.x2.a vdd vdd sky130_fd_pr__pfet_01v8 w=1 l=0.15 ad=0.29 as=0.29 pd=2.58 ps=2.58
xb.x2.xnsi.xmp2 xb.x2.sib xb.x2.bb vdd vdd sky130_fd_pr__pfet_01v8 w=1 l=0.15 ad=0.29 as=0.29 pd=2.58 ps=2.58
xb.x2.xnsi.xmp3 xb.x2.sib xb.pb vdd vdd sky130_fd_pr__pfet_01v8 w=1 l=0.15 ad=0.29 as=0.29 pd=2.58 ps=2.58
xb.x2.xnsi.xmn1 xb.x2.sib xb.x2.a xb.x2.xnsi.n1 0 sky130_fd_pr__nfet_01v8 w=1.26 l=0.15 ad=0.3654 as=0.3654 pd=3.1 ps=3.1
xb.x2.xnsi.xmn2 xb.x2.xnsi.n1 xb.x2.bb xb.x2.xnsi.n2 0 sky130_fd_pr__nfet_01v8 w=1.26 l=0.15 ad=0.3654 as=0.3654 pd=3.1 ps=3.1
xb.x2.xnsi.xmn3 xb.x2.xnsi.n2 xb.pb 0 0 sky130_fd_pr__nfet_01v8 w=1.26 l=0.15 ad=0.3654 as=0.3654 pd=3.1 ps=3.1
xb.x2.xisi.xmp xb.x2.si xb.x2.sib vdd vdd sky130_fd_pr__pfet_01v8 w=1 l=0.15 ad=0.29 as=0.29 pd=2.58 ps=2.58
xb.x2.xisi.xmn xb.x2.si xb.x2.sib 0 0 sky130_fd_pr__nfet_01v8 w=0.42 l=0.15 ad=0.1218 as=0.1218 pd=1.42 ps=1.42
xb.x2.xisd.xmp xb.x2.sd xb.x2.si vdd vdd sky130_fd_pr__pfet_01v8 w=1 l=0.15 ad=0.29 as=0.29 pd=2.58 ps=2.58
xb.x2.xisd.xmn xb.x2.sd xb.x2.si 0 0 sky130_fd_pr__nfet_01v8 w=0.42 l=0.15 ad=0.1218 as=0.1218 pd=1.42 ps=1.42
i.xb.ibm xb.ibm 0 10u
c.xb.cq xb.vq 0 {cq}
r.xb.rleak xb.vq vr0 {rleak}
v.xb.vnzm xb.nzm 0 dc 0
r.xb.rnzm xb.nzm 0 1k noisy=0
b.xb.bvrm xb.vrefmn0 0 v = v(xb.vrefm) + v(xb.nzm)
r.xb.rvrm xb.vrefmn0 xb.vrefmn 1k noisy=0
c.xb.cvrm xb.vrefmn 0 20f
xb.xcmpm.xmb xb.ibm xb.ibm vdd vdd sky130_fd_pr__pfet_01v8 w=8 l=2 ad=2.32 as=2.32 pd=16.58 ps=16.58
xb.xcmpm.xmt xb.xcmpm.tail xb.ibm vdd vdd sky130_fd_pr__pfet_01v8 w=16 l=2 ad=3.48 as=3.48 pd=24.87 ps=24.87
xb.xcmpm.xm1 xb.xcmpm.o1m xb.vq xb.xcmpm.tail vdd sky130_fd_pr__pfet_01v8_lvt w={(16)} l={(4)} ad=3.48 as=3.48 pd=24.87 ps=24.87
xb.xcmpm.xm2 xb.xcmpm.o1 xb.vrefmn xb.xcmpm.tail vdd sky130_fd_pr__pfet_01v8_lvt w={(16)} l={(4)} ad=3.48 as=3.48 pd=24.87 ps=24.87
xb.xcmpm.xm3 xb.xcmpm.o1m xb.xcmpm.o1m 0 0 sky130_fd_pr__nfet_01v8 w=2 l=1 ad=0.58 as=0.58 pd=4.58 ps=4.58
xb.xcmpm.xm4 xb.xcmpm.o1 xb.xcmpm.o1m 0 0 sky130_fd_pr__nfet_01v8 w=2 l=1 ad=0.58 as=0.58 pd=4.58 ps=4.58
xb.xcmpm.xm5 xb.xcmpm.o2 xb.xcmpm.o1 0 0 sky130_fd_pr__nfet_01v8 w=2 l=0.5 ad=0.58 as=0.58 pd=4.58 ps=4.58
xb.xcmpm.xm6 xb.xcmpm.o2 xb.ibm vdd vdd sky130_fd_pr__pfet_01v8 w=16 l=2 ad=3.48 as=3.48 pd=24.87 ps=24.87
xb.xcmpm.xi1.xmp xb.xcmpm.o3 xb.xcmpm.o2 vdd vdd sky130_fd_pr__pfet_01v8 w=1 l=0.15 ad=0.29 as=0.29 pd=2.58 ps=2.58
xb.xcmpm.xi1.xmn xb.xcmpm.o3 xb.xcmpm.o2 0 0 sky130_fd_pr__nfet_01v8 w=0.42 l=0.15 ad=0.1218 as=0.1218 pd=1.42 ps=1.42
xb.xcmpm.xi2.xmp xb.cmpm xb.xcmpm.o3 vdd vdd sky130_fd_pr__pfet_01v8 w=1 l=0.15 ad=0.29 as=0.29 pd=2.58 ps=2.58
xb.xcmpm.xi2.xmn xb.cmpm xb.xcmpm.o3 0 0 sky130_fd_pr__nfet_01v8 w=0.42 l=0.15 ad=0.1218 as=0.1218 pd=1.42 ps=1.42
xb.xicm.xmp xb.cmpmb xb.cmpm vdd vdd sky130_fd_pr__pfet_01v8 w=1 l=0.15 ad=0.29 as=0.29 pd=2.58 ps=2.58
xb.xicm.xmn xb.cmpmb xb.cmpm 0 0 sky130_fd_pr__nfet_01v8 w=0.42 l=0.15 ad=0.1218 as=0.1218 pd=1.42 ps=1.42
xb.xnsp.xmp1 xb.sbp xb.cmpm vdd vdd sky130_fd_pr__pfet_01v8 w=1 l=0.15 ad=0.29 as=0.29 pd=2.58 ps=2.58
xb.xnsp.xmp2 xb.sbp xb.pbdel vdd vdd sky130_fd_pr__pfet_01v8 w=1 l=0.15 ad=0.29 as=0.29 pd=2.58 ps=2.58
xb.xnsp.xmn1 xb.sbp xb.cmpm xb.xnsp.n1 0 sky130_fd_pr__nfet_01v8 w=0.84 l=0.15 ad=0.2436 as=0.2436 pd=2.26 ps=2.26
xb.xnsp.xmn2 xb.xnsp.n1 xb.pbdel 0 0 sky130_fd_pr__nfet_01v8 w=0.84 l=0.15 ad=0.2436 as=0.2436 pd=2.26 ps=2.26
xb.xnrp.xmp1 xb.rbp xb.cmpmb vdd vdd sky130_fd_pr__pfet_01v8 w=1 l=0.15 ad=0.29 as=0.29 pd=2.58 ps=2.58
xb.xnrp.xmp2 xb.rbp xb.pdel vdd vdd sky130_fd_pr__pfet_01v8 w=1 l=0.15 ad=0.29 as=0.29 pd=2.58 ps=2.58
xb.xnrp.xmn1 xb.rbp xb.cmpmb xb.xnrp.n1 0 sky130_fd_pr__nfet_01v8 w=0.84 l=0.15 ad=0.2436 as=0.2436 pd=2.26 ps=2.26
xb.xnrp.xmn2 xb.xnrp.n1 xb.pdel 0 0 sky130_fd_pr__nfet_01v8 w=0.84 l=0.15 ad=0.2436 as=0.2436 pd=2.26 ps=2.26
xb.xlp.x1.xmp1 xb.p xb.sbp vdd vdd sky130_fd_pr__pfet_01v8 w=1 l=0.15 ad=0.29 as=0.29 pd=2.58 ps=2.58
xb.xlp.x1.xmp2 xb.p xb.pb vdd vdd sky130_fd_pr__pfet_01v8 w=1 l=0.15 ad=0.29 as=0.29 pd=2.58 ps=2.58
xb.xlp.x1.xmn1 xb.p xb.sbp xb.xlp.x1.n1 0 sky130_fd_pr__nfet_01v8 w=0.84 l=0.15 ad=0.2436 as=0.2436 pd=2.26 ps=2.26
xb.xlp.x1.xmn2 xb.xlp.x1.n1 xb.pb 0 0 sky130_fd_pr__nfet_01v8 w=0.84 l=0.15 ad=0.2436 as=0.2436 pd=2.26 ps=2.26
xb.xlp.x2.xmp1 xb.pb xb.rbp vdd vdd sky130_fd_pr__pfet_01v8 w=1 l=0.15 ad=0.29 as=0.29 pd=2.58 ps=2.58
xb.xlp.x2.xmp2 xb.pb xb.p vdd vdd sky130_fd_pr__pfet_01v8 w=1 l=0.15 ad=0.29 as=0.29 pd=2.58 ps=2.58
xb.xlp.x2.xmn1 xb.pb xb.rbp xb.xlp.x2.n1 0 sky130_fd_pr__nfet_01v8 w=0.84 l=0.15 ad=0.2436 as=0.2436 pd=2.26 ps=2.26
xb.xlp.x2.xmn2 xb.xlp.x2.n1 xb.p 0 0 sky130_fd_pr__nfet_01v8 w=0.84 l=0.15 ad=0.2436 as=0.2436 pd=2.26 ps=2.26
r.xb.rdp xb.p xb.pd1 100k
c.xb.cdp xb.pd1 0 2p
xb.xip1.xmp xb.pbdel xb.pd1 vdd vdd sky130_fd_pr__pfet_01v8 w=1 l=0.15 ad=0.29 as=0.29 pd=2.58 ps=2.58
xb.xip1.xmn xb.pbdel xb.pd1 0 0 sky130_fd_pr__nfet_01v8 w=0.42 l=0.15 ad=0.1218 as=0.1218 pd=1.42 ps=1.42
xb.xip2.xmp xb.pdel xb.pbdel vdd vdd sky130_fd_pr__pfet_01v8 w=1 l=0.15 ad=0.29 as=0.29 pd=2.58 ps=2.58
xb.xip2.xmn xb.pdel xb.pbdel 0 0 sky130_fd_pr__nfet_01v8 w=0.42 l=0.15 ad=0.1218 as=0.1218 pd=1.42 ps=1.42
xb.xmm1n xb.vrefm xb.pb vfire 0 sky130_fd_pr__nfet_01v8 w=1 l=0.15 ad=0.29 as=0.29 pd=2.58 ps=2.58
xb.xmm1p xb.vrefm xb.p vfire vdd sky130_fd_pr__pfet_01v8 w=2 l=0.15 ad=0.58 as=0.58 pd=4.58 ps=4.58
xb.xmm2n xb.vrefm xb.p vreopen 0 sky130_fd_pr__nfet_01v8 w=1 l=0.15 ad=0.29 as=0.29 pd=2.58 ps=2.58
xb.xmm2p xb.vrefm xb.pb vreopen vdd sky130_fd_pr__pfet_01v8 w=2 l=0.15 ad=0.58 as=0.58 pd=4.58 ps=4.58
vinitc1 vinitc1 0 0.3895
vksc1 ksc1 0 pulse(0 1 1.0 1n 1n 1.9999e-05 2)
vkrc1 krc1 0 pulse(1 0 1.0 1n 1n 0.000121 2)
vkpc1 kpc1 0 pulse(0 1 1.0 1n 1n 0.00012 2)
vtsc1 tsc1 0 dc 1.0
vampc1 ampc1 0 dc 1
vinitc2 vinitc2 0 0.3895
vksc2 ksc2 0 pulse(0 1 1.0 1n 1n 1.9999e-05 2)
vkrc2 krc2 0 pulse(1 0 1.0 1n 1n 0.000121 2)
vkpc2 kpc2 0 pulse(0 1 1.0 1n 1n 0.00012 2)
vtsc2 tsc2 0 dc 1.0
vampc2 ampc2 0 dc 1
xc.x1.xmin 0 0 0 0 sky130_fd_pr__nfet_01v8 w={wg} l={lg} ad=7.25 as=7.25 pd=51.45 ps=51.45
xc.x1.xmout 0 0 0 0 sky130_fd_pr__nfet_01v8 w={wg} l={lg} ad=7.25 as=7.25 pd=51.45 ps=51.45
xc.x1.xnad.xmp1 0 0 0 0 sky130_fd_pr__pfet_01v8 w=1 l=0.15 ad=0.29 as=0.29 pd=2.58 ps=2.58
xc.x1.xnad.xmp2 0 0 0 0 sky130_fd_pr__pfet_01v8 w=1 l=0.15 ad=0.29 as=0.29 pd=2.58 ps=2.58
xc.x1.xnad.xmn1 0 0 0 0 sky130_fd_pr__nfet_01v8 w=0.84 l=0.15 ad=0.2436 as=0.2436 pd=2.26 ps=2.26
xc.x1.xnad.xmn2 0 0 0 0 sky130_fd_pr__nfet_01v8 w=0.84 l=0.15 ad=0.2436 as=0.2436 pd=2.26 ps=2.26
xc.x1.xiad.xmp 0 0 0 0 sky130_fd_pr__pfet_01v8 w=1 l=0.15 ad=0.29 as=0.29 pd=2.58 ps=2.58
xc.x1.xiad.xmn 0 0 0 0 sky130_fd_pr__nfet_01v8 w=0.42 l=0.15 ad=0.1218 as=0.1218 pd=1.42 ps=1.42
xc.x1.xms1 0 0 0 0 sky130_fd_pr__nfet_01v8 w=1 l=0.15 ad=0.29 as=0.29 pd=2.58 ps=2.58
xc.x1.xms2 0 0 0 0 sky130_fd_pr__nfet_01v8 w=1 l=0.15 ad=0.29 as=0.29 pd=2.58 ps=2.58
xc.x1.xmpre 0 0 0 0 sky130_fd_pr__pfet_01v8 w=2 l=0.5 ad=0.58 as=0.58 pd=4.58 ps=4.58
xc.x1.xmbd 0 0 0 0 sky130_fd_pr__nfet_01v8 w=0.42 l=8 ad=0.1218 as=0.1218 pd=1.42 ps=1.42
xc.x1.xmdis 0 0 0 0 sky130_fd_pr__nfet_01v8 w=0.42 l=8 ad=0.1218 as=0.1218 pd=1.42 ps=1.42
xc.x1.xmsi 0 0 0 0 sky130_fd_pr__nfet_01v8 w=1 l=0.15 ad=0.29 as=0.29 pd=2.58 ps=2.58
xc.x1.xmsd 0 0 0 0 sky130_fd_pr__nfet_01v8 w=1 l=0.15 ad=0.29 as=0.29 pd=2.58 ps=2.58
xc.x1.xop.xmb 0 0 0 0 sky130_fd_pr__pfet_01v8 w=8 l=2 ad=2.32 as=2.32 pd=16.58 ps=16.58
xc.x1.xop.xmt 0 0 0 0 sky130_fd_pr__pfet_01v8 w=8 l=2 ad=2.32 as=2.32 pd=16.58 ps=16.58
xc.x1.xop.xm1 0 0 0 0 sky130_fd_pr__pfet_01v8_lvt w=16 l=1 ad=3.48 as=3.48 pd=24.87 ps=24.87
xc.x1.xop.xm2 0 0 0 0 sky130_fd_pr__pfet_01v8_lvt w=16 l=1 ad=3.48 as=3.48 pd=24.87 ps=24.87
xc.x1.xop.xm3 0 0 0 0 sky130_fd_pr__nfet_01v8 w=4 l=2 ad=1.16 as=1.16 pd=8.58 ps=8.58
xc.x1.xop.xm4 0 0 0 0 sky130_fd_pr__nfet_01v8 w=4 l=2 ad=1.16 as=1.16 pd=8.58 ps=8.58
xc.x1.xop.xm5 0 0 0 0 sky130_fd_pr__nfet_01v8 w=16 l=1 ad=3.48 as=3.48 pd=24.87 ps=24.87
xc.x1.xop.xm6 0 0 0 0 sky130_fd_pr__pfet_01v8 w=32 l=2 ad=5.8 as=5.8 pd=41.45 ps=41.45
xc.x1.xcmps.xmb 0 0 0 0 sky130_fd_pr__pfet_01v8 w=8 l=2 ad=2.32 as=2.32 pd=16.58 ps=16.58
xc.x1.xcmps.xmt 0 0 0 0 sky130_fd_pr__pfet_01v8 w=16 l=2 ad=3.48 as=3.48 pd=24.87 ps=24.87
xc.x1.xcmps.xm1 0 0 0 0 sky130_fd_pr__pfet_01v8_lvt w={(4)} l={(1)} ad=1.16 as=1.16 pd=8.58 ps=8.58
xc.x1.xcmps.xm2 0 0 0 0 sky130_fd_pr__pfet_01v8_lvt w={(4)} l={(1)} ad=1.16 as=1.16 pd=8.58 ps=8.58
xc.x1.xcmps.xm3 0 0 0 0 sky130_fd_pr__nfet_01v8 w=2 l=1 ad=0.58 as=0.58 pd=4.58 ps=4.58
xc.x1.xcmps.xm4 0 0 0 0 sky130_fd_pr__nfet_01v8 w=2 l=1 ad=0.58 as=0.58 pd=4.58 ps=4.58
xc.x1.xcmps.xm5 0 0 0 0 sky130_fd_pr__nfet_01v8 w=2 l=0.5 ad=0.58 as=0.58 pd=4.58 ps=4.58
xc.x1.xcmps.xm6 0 0 0 0 sky130_fd_pr__pfet_01v8 w=16 l=2 ad=3.48 as=3.48 pd=24.87 ps=24.87
xc.x1.xcmps.xi1.xmp 0 0 0 0 sky130_fd_pr__pfet_01v8 w=1 l=0.15 ad=0.29 as=0.29 pd=2.58 ps=2.58
xc.x1.xcmps.xi1.xmn 0 0 0 0 sky130_fd_pr__nfet_01v8 w=0.42 l=0.15 ad=0.1218 as=0.1218 pd=1.42 ps=1.42
xc.x1.xcmps.xi2.xmp 0 0 0 0 sky130_fd_pr__pfet_01v8 w=1 l=0.15 ad=0.29 as=0.29 pd=2.58 ps=2.58
xc.x1.xcmps.xi2.xmn 0 0 0 0 sky130_fd_pr__nfet_01v8 w=0.42 l=0.15 ad=0.1218 as=0.1218 pd=1.42 ps=1.42
xc.x1.xmr1n 0 0 0 0 sky130_fd_pr__nfet_01v8 w=1 l=0.15 ad=0.29 as=0.29 pd=2.58 ps=2.58
xc.x1.xmr1p 0 0 0 0 sky130_fd_pr__pfet_01v8 w=2 l=0.15 ad=0.58 as=0.58 pd=4.58 ps=4.58
xc.x1.xmr2n 0 0 0 0 sky130_fd_pr__nfet_01v8 w=1 l=0.15 ad=0.29 as=0.29 pd=2.58 ps=2.58
xc.x1.xmr2p 0 0 0 0 sky130_fd_pr__pfet_01v8 w=2 l=0.15 ad=0.58 as=0.58 pd=4.58 ps=4.58
xc.x1.xien.xmp 0 0 0 0 sky130_fd_pr__pfet_01v8 w=1 l=0.15 ad=0.29 as=0.29 pd=2.58 ps=2.58
xc.x1.xien.xmn 0 0 0 0 sky130_fd_pr__nfet_01v8 w=0.42 l=0.15 ad=0.1218 as=0.1218 pd=1.42 ps=1.42
xc.x1.xicb.xmp 0 0 0 0 sky130_fd_pr__pfet_01v8 w=1 l=0.15 ad=0.29 as=0.29 pd=2.58 ps=2.58
xc.x1.xicb.xmn 0 0 0 0 sky130_fd_pr__nfet_01v8 w=0.42 l=0.15 ad=0.1218 as=0.1218 pd=1.42 ps=1.42
xc.x1.xnsa.xmp1 0 0 0 0 sky130_fd_pr__pfet_01v8 w=1 l=0.15 ad=0.29 as=0.29 pd=2.58 ps=2.58
xc.x1.xnsa.xmp2 0 0 0 0 sky130_fd_pr__pfet_01v8 w=1 l=0.15 ad=0.29 as=0.29 pd=2.58 ps=2.58
xc.x1.xnsa.xmn1 0 0 0 0 sky130_fd_pr__nfet_01v8 w=0.84 l=0.15 ad=0.2436 as=0.2436 pd=2.26 ps=2.26
xc.x1.xnsa.xmn2 0 0 0 0 sky130_fd_pr__nfet_01v8 w=0.84 l=0.15 ad=0.2436 as=0.2436 pd=2.26 ps=2.26
xc.x1.xla.x1.xmp1 0 0 0 0 sky130_fd_pr__pfet_01v8 w=1 l=0.15 ad=0.29 as=0.29 pd=2.58 ps=2.58
xc.x1.xla.x1.xmp2 0 0 0 0 sky130_fd_pr__pfet_01v8 w=1 l=0.15 ad=0.29 as=0.29 pd=2.58 ps=2.58
xc.x1.xla.x1.xmn1 0 0 0 0 sky130_fd_pr__nfet_01v8 w=0.84 l=0.15 ad=0.2436 as=0.2436 pd=2.26 ps=2.26
xc.x1.xla.x1.xmn2 0 0 0 0 sky130_fd_pr__nfet_01v8 w=0.84 l=0.15 ad=0.2436 as=0.2436 pd=2.26 ps=2.26
xc.x1.xla.x2.xmp1 0 0 0 0 sky130_fd_pr__pfet_01v8 w=1 l=0.15 ad=0.29 as=0.29 pd=2.58 ps=2.58
xc.x1.xla.x2.xmp2 0 0 0 0 sky130_fd_pr__pfet_01v8 w=1 l=0.15 ad=0.29 as=0.29 pd=2.58 ps=2.58
xc.x1.xla.x2.xmn1 0 0 0 0 sky130_fd_pr__nfet_01v8 w=0.84 l=0.15 ad=0.2436 as=0.2436 pd=2.26 ps=2.26
xc.x1.xla.x2.xmn2 0 0 0 0 sky130_fd_pr__nfet_01v8 w=0.84 l=0.15 ad=0.2436 as=0.2436 pd=2.26 ps=2.26
xc.x1.xia1.xmp 0 0 0 0 sky130_fd_pr__pfet_01v8 w=1 l=0.15 ad=0.29 as=0.29 pd=2.58 ps=2.58
xc.x1.xia1.xmn 0 0 0 0 sky130_fd_pr__nfet_01v8 w=0.42 l=0.15 ad=0.1218 as=0.1218 pd=1.42 ps=1.42
xc.x1.xia2.xmp 0 0 0 0 sky130_fd_pr__pfet_01v8 w=1 l=0.15 ad=0.29 as=0.29 pd=2.58 ps=2.58
xc.x1.xia2.xmn 0 0 0 0 sky130_fd_pr__nfet_01v8 w=0.42 l=0.15 ad=0.1218 as=0.1218 pd=1.42 ps=1.42
xc.x1.xnsc.xmp1 0 0 0 0 sky130_fd_pr__pfet_01v8 w=1 l=0.15 ad=0.29 as=0.29 pd=2.58 ps=2.58
xc.x1.xnsc.xmp2 0 0 0 0 sky130_fd_pr__pfet_01v8 w=1 l=0.15 ad=0.29 as=0.29 pd=2.58 ps=2.58
xc.x1.xnsc.xmn1 0 0 0 0 sky130_fd_pr__nfet_01v8 w=0.84 l=0.15 ad=0.2436 as=0.2436 pd=2.26 ps=2.26
xc.x1.xnsc.xmn2 0 0 0 0 sky130_fd_pr__nfet_01v8 w=0.84 l=0.15 ad=0.2436 as=0.2436 pd=2.26 ps=2.26
xc.x1.xlc.x1.xmp1 0 0 0 0 sky130_fd_pr__pfet_01v8 w=1 l=0.15 ad=0.29 as=0.29 pd=2.58 ps=2.58
xc.x1.xlc.x1.xmp2 0 0 0 0 sky130_fd_pr__pfet_01v8 w=1 l=0.15 ad=0.29 as=0.29 pd=2.58 ps=2.58
xc.x1.xlc.x1.xmn1 0 0 0 0 sky130_fd_pr__nfet_01v8 w=0.84 l=0.15 ad=0.2436 as=0.2436 pd=2.26 ps=2.26
xc.x1.xlc.x1.xmn2 0 0 0 0 sky130_fd_pr__nfet_01v8 w=0.84 l=0.15 ad=0.2436 as=0.2436 pd=2.26 ps=2.26
xc.x1.xlc.x2.xmp1 0 0 0 0 sky130_fd_pr__pfet_01v8 w=1 l=0.15 ad=0.29 as=0.29 pd=2.58 ps=2.58
xc.x1.xlc.x2.xmp2 0 0 0 0 sky130_fd_pr__pfet_01v8 w=1 l=0.15 ad=0.29 as=0.29 pd=2.58 ps=2.58
xc.x1.xlc.x2.xmn1 0 0 0 0 sky130_fd_pr__nfet_01v8 w=0.84 l=0.15 ad=0.2436 as=0.2436 pd=2.26 ps=2.26
xc.x1.xlc.x2.xmn2 0 0 0 0 sky130_fd_pr__nfet_01v8 w=0.84 l=0.15 ad=0.2436 as=0.2436 pd=2.26 ps=2.26
xc.x1.xid1.xmp 0 0 0 0 sky130_fd_pr__pfet_01v8 w=1 l=0.15 ad=0.29 as=0.29 pd=2.58 ps=2.58
xc.x1.xid1.xmn 0 0 0 0 sky130_fd_pr__nfet_01v8 w=0.42 l=0.15 ad=0.1218 as=0.1218 pd=1.42 ps=1.42
xc.x1.xid2.xmp 0 0 0 0 sky130_fd_pr__pfet_01v8 w=1 l=0.15 ad=0.29 as=0.29 pd=2.58 ps=2.58
xc.x1.xid2.xmn 0 0 0 0 sky130_fd_pr__nfet_01v8 w=0.42 l=0.15 ad=0.1218 as=0.1218 pd=1.42 ps=1.42
xc.x1.xnsb.xmp1 0 0 0 0 sky130_fd_pr__pfet_01v8 w=1 l=0.15 ad=0.29 as=0.29 pd=2.58 ps=2.58
xc.x1.xnsb.xmp2 0 0 0 0 sky130_fd_pr__pfet_01v8 w=1 l=0.15 ad=0.29 as=0.29 pd=2.58 ps=2.58
xc.x1.xnsb.xmn1 0 0 0 0 sky130_fd_pr__nfet_01v8 w=0.84 l=0.15 ad=0.2436 as=0.2436 pd=2.26 ps=2.26
xc.x1.xnsb.xmn2 0 0 0 0 sky130_fd_pr__nfet_01v8 w=0.84 l=0.15 ad=0.2436 as=0.2436 pd=2.26 ps=2.26
xc.x1.xlb.x1.xmp1 0 0 0 0 sky130_fd_pr__pfet_01v8 w=1 l=0.15 ad=0.29 as=0.29 pd=2.58 ps=2.58
xc.x1.xlb.x1.xmp2 0 0 0 0 sky130_fd_pr__pfet_01v8 w=1 l=0.15 ad=0.29 as=0.29 pd=2.58 ps=2.58
xc.x1.xlb.x1.xmn1 0 0 0 0 sky130_fd_pr__nfet_01v8 w=0.84 l=0.15 ad=0.2436 as=0.2436 pd=2.26 ps=2.26
xc.x1.xlb.x1.xmn2 0 0 0 0 sky130_fd_pr__nfet_01v8 w=0.84 l=0.15 ad=0.2436 as=0.2436 pd=2.26 ps=2.26
xc.x1.xlb.x2.xmp1 0 0 0 0 sky130_fd_pr__pfet_01v8 w=1 l=0.15 ad=0.29 as=0.29 pd=2.58 ps=2.58
xc.x1.xlb.x2.xmp2 0 0 0 0 sky130_fd_pr__pfet_01v8 w=1 l=0.15 ad=0.29 as=0.29 pd=2.58 ps=2.58
xc.x1.xlb.x2.xmn1 0 0 0 0 sky130_fd_pr__nfet_01v8 w=0.84 l=0.15 ad=0.2436 as=0.2436 pd=2.26 ps=2.26
xc.x1.xlb.x2.xmn2 0 0 0 0 sky130_fd_pr__nfet_01v8 w=0.84 l=0.15 ad=0.2436 as=0.2436 pd=2.26 ps=2.26
xc.x1.xnsi.xmp1 0 0 0 0 sky130_fd_pr__pfet_01v8 w=1 l=0.15 ad=0.29 as=0.29 pd=2.58 ps=2.58
xc.x1.xnsi.xmp2 0 0 0 0 sky130_fd_pr__pfet_01v8 w=1 l=0.15 ad=0.29 as=0.29 pd=2.58 ps=2.58
xc.x1.xnsi.xmp3 0 0 0 0 sky130_fd_pr__pfet_01v8 w=1 l=0.15 ad=0.29 as=0.29 pd=2.58 ps=2.58
xc.x1.xnsi.xmn1 0 0 0 0 sky130_fd_pr__nfet_01v8 w=1.26 l=0.15 ad=0.3654 as=0.3654 pd=3.1 ps=3.1
xc.x1.xnsi.xmn2 0 0 0 0 sky130_fd_pr__nfet_01v8 w=1.26 l=0.15 ad=0.3654 as=0.3654 pd=3.1 ps=3.1
xc.x1.xnsi.xmn3 0 0 0 0 sky130_fd_pr__nfet_01v8 w=1.26 l=0.15 ad=0.3654 as=0.3654 pd=3.1 ps=3.1
xc.x1.xisi.xmp 0 0 0 0 sky130_fd_pr__pfet_01v8 w=1 l=0.15 ad=0.29 as=0.29 pd=2.58 ps=2.58
xc.x1.xisi.xmn 0 0 0 0 sky130_fd_pr__nfet_01v8 w=0.42 l=0.15 ad=0.1218 as=0.1218 pd=1.42 ps=1.42
xc.x1.xisd.xmp 0 0 0 0 sky130_fd_pr__pfet_01v8 w=1 l=0.15 ad=0.29 as=0.29 pd=2.58 ps=2.58
xc.x1.xisd.xmn 0 0 0 0 sky130_fd_pr__nfet_01v8 w=0.42 l=0.15 ad=0.1218 as=0.1218 pd=1.42 ps=1.42
xc.x2.xmin 0 0 0 0 sky130_fd_pr__nfet_01v8 w={wg} l={lg} ad=7.25 as=7.25 pd=51.45 ps=51.45
xc.x2.xmout 0 0 0 0 sky130_fd_pr__nfet_01v8 w={wg} l={lg} ad=7.25 as=7.25 pd=51.45 ps=51.45
xc.x2.xnad.xmp1 0 0 0 0 sky130_fd_pr__pfet_01v8 w=1 l=0.15 ad=0.29 as=0.29 pd=2.58 ps=2.58
xc.x2.xnad.xmp2 0 0 0 0 sky130_fd_pr__pfet_01v8 w=1 l=0.15 ad=0.29 as=0.29 pd=2.58 ps=2.58
xc.x2.xnad.xmn1 0 0 0 0 sky130_fd_pr__nfet_01v8 w=0.84 l=0.15 ad=0.2436 as=0.2436 pd=2.26 ps=2.26
xc.x2.xnad.xmn2 0 0 0 0 sky130_fd_pr__nfet_01v8 w=0.84 l=0.15 ad=0.2436 as=0.2436 pd=2.26 ps=2.26
xc.x2.xiad.xmp 0 0 0 0 sky130_fd_pr__pfet_01v8 w=1 l=0.15 ad=0.29 as=0.29 pd=2.58 ps=2.58
xc.x2.xiad.xmn 0 0 0 0 sky130_fd_pr__nfet_01v8 w=0.42 l=0.15 ad=0.1218 as=0.1218 pd=1.42 ps=1.42
xc.x2.xms1 0 0 0 0 sky130_fd_pr__nfet_01v8 w=1 l=0.15 ad=0.29 as=0.29 pd=2.58 ps=2.58
xc.x2.xms2 0 0 0 0 sky130_fd_pr__nfet_01v8 w=1 l=0.15 ad=0.29 as=0.29 pd=2.58 ps=2.58
xc.x2.xmpre 0 0 0 0 sky130_fd_pr__pfet_01v8 w=2 l=0.5 ad=0.58 as=0.58 pd=4.58 ps=4.58
xc.x2.xmbd 0 0 0 0 sky130_fd_pr__nfet_01v8 w=0.42 l=8 ad=0.1218 as=0.1218 pd=1.42 ps=1.42
xc.x2.xmdis 0 0 0 0 sky130_fd_pr__nfet_01v8 w=0.42 l=8 ad=0.1218 as=0.1218 pd=1.42 ps=1.42
xc.x2.xmsi 0 0 0 0 sky130_fd_pr__nfet_01v8 w=1 l=0.15 ad=0.29 as=0.29 pd=2.58 ps=2.58
xc.x2.xmsd 0 0 0 0 sky130_fd_pr__nfet_01v8 w=1 l=0.15 ad=0.29 as=0.29 pd=2.58 ps=2.58
xc.x2.xop.xmb 0 0 0 0 sky130_fd_pr__pfet_01v8 w=8 l=2 ad=2.32 as=2.32 pd=16.58 ps=16.58
xc.x2.xop.xmt 0 0 0 0 sky130_fd_pr__pfet_01v8 w=8 l=2 ad=2.32 as=2.32 pd=16.58 ps=16.58
xc.x2.xop.xm1 0 0 0 0 sky130_fd_pr__pfet_01v8_lvt w=16 l=1 ad=3.48 as=3.48 pd=24.87 ps=24.87
xc.x2.xop.xm2 0 0 0 0 sky130_fd_pr__pfet_01v8_lvt w=16 l=1 ad=3.48 as=3.48 pd=24.87 ps=24.87
xc.x2.xop.xm3 0 0 0 0 sky130_fd_pr__nfet_01v8 w=4 l=2 ad=1.16 as=1.16 pd=8.58 ps=8.58
xc.x2.xop.xm4 0 0 0 0 sky130_fd_pr__nfet_01v8 w=4 l=2 ad=1.16 as=1.16 pd=8.58 ps=8.58
xc.x2.xop.xm5 0 0 0 0 sky130_fd_pr__nfet_01v8 w=16 l=1 ad=3.48 as=3.48 pd=24.87 ps=24.87
xc.x2.xop.xm6 0 0 0 0 sky130_fd_pr__pfet_01v8 w=32 l=2 ad=5.8 as=5.8 pd=41.45 ps=41.45
xc.x2.xcmps.xmb 0 0 0 0 sky130_fd_pr__pfet_01v8 w=8 l=2 ad=2.32 as=2.32 pd=16.58 ps=16.58
xc.x2.xcmps.xmt 0 0 0 0 sky130_fd_pr__pfet_01v8 w=16 l=2 ad=3.48 as=3.48 pd=24.87 ps=24.87
xc.x2.xcmps.xm1 0 0 0 0 sky130_fd_pr__pfet_01v8_lvt w={(4)} l={(1)} ad=1.16 as=1.16 pd=8.58 ps=8.58
xc.x2.xcmps.xm2 0 0 0 0 sky130_fd_pr__pfet_01v8_lvt w={(4)} l={(1)} ad=1.16 as=1.16 pd=8.58 ps=8.58
xc.x2.xcmps.xm3 0 0 0 0 sky130_fd_pr__nfet_01v8 w=2 l=1 ad=0.58 as=0.58 pd=4.58 ps=4.58
xc.x2.xcmps.xm4 0 0 0 0 sky130_fd_pr__nfet_01v8 w=2 l=1 ad=0.58 as=0.58 pd=4.58 ps=4.58
xc.x2.xcmps.xm5 0 0 0 0 sky130_fd_pr__nfet_01v8 w=2 l=0.5 ad=0.58 as=0.58 pd=4.58 ps=4.58
xc.x2.xcmps.xm6 0 0 0 0 sky130_fd_pr__pfet_01v8 w=16 l=2 ad=3.48 as=3.48 pd=24.87 ps=24.87
xc.x2.xcmps.xi1.xmp 0 0 0 0 sky130_fd_pr__pfet_01v8 w=1 l=0.15 ad=0.29 as=0.29 pd=2.58 ps=2.58
xc.x2.xcmps.xi1.xmn 0 0 0 0 sky130_fd_pr__nfet_01v8 w=0.42 l=0.15 ad=0.1218 as=0.1218 pd=1.42 ps=1.42
xc.x2.xcmps.xi2.xmp 0 0 0 0 sky130_fd_pr__pfet_01v8 w=1 l=0.15 ad=0.29 as=0.29 pd=2.58 ps=2.58
xc.x2.xcmps.xi2.xmn 0 0 0 0 sky130_fd_pr__nfet_01v8 w=0.42 l=0.15 ad=0.1218 as=0.1218 pd=1.42 ps=1.42
xc.x2.xmr1n 0 0 0 0 sky130_fd_pr__nfet_01v8 w=1 l=0.15 ad=0.29 as=0.29 pd=2.58 ps=2.58
xc.x2.xmr1p 0 0 0 0 sky130_fd_pr__pfet_01v8 w=2 l=0.15 ad=0.58 as=0.58 pd=4.58 ps=4.58
xc.x2.xmr2n 0 0 0 0 sky130_fd_pr__nfet_01v8 w=1 l=0.15 ad=0.29 as=0.29 pd=2.58 ps=2.58
xc.x2.xmr2p 0 0 0 0 sky130_fd_pr__pfet_01v8 w=2 l=0.15 ad=0.58 as=0.58 pd=4.58 ps=4.58
xc.x2.xien.xmp 0 0 0 0 sky130_fd_pr__pfet_01v8 w=1 l=0.15 ad=0.29 as=0.29 pd=2.58 ps=2.58
xc.x2.xien.xmn 0 0 0 0 sky130_fd_pr__nfet_01v8 w=0.42 l=0.15 ad=0.1218 as=0.1218 pd=1.42 ps=1.42
xc.x2.xicb.xmp 0 0 0 0 sky130_fd_pr__pfet_01v8 w=1 l=0.15 ad=0.29 as=0.29 pd=2.58 ps=2.58
xc.x2.xicb.xmn 0 0 0 0 sky130_fd_pr__nfet_01v8 w=0.42 l=0.15 ad=0.1218 as=0.1218 pd=1.42 ps=1.42
xc.x2.xnsa.xmp1 0 0 0 0 sky130_fd_pr__pfet_01v8 w=1 l=0.15 ad=0.29 as=0.29 pd=2.58 ps=2.58
xc.x2.xnsa.xmp2 0 0 0 0 sky130_fd_pr__pfet_01v8 w=1 l=0.15 ad=0.29 as=0.29 pd=2.58 ps=2.58
xc.x2.xnsa.xmn1 0 0 0 0 sky130_fd_pr__nfet_01v8 w=0.84 l=0.15 ad=0.2436 as=0.2436 pd=2.26 ps=2.26
xc.x2.xnsa.xmn2 0 0 0 0 sky130_fd_pr__nfet_01v8 w=0.84 l=0.15 ad=0.2436 as=0.2436 pd=2.26 ps=2.26
xc.x2.xla.x1.xmp1 0 0 0 0 sky130_fd_pr__pfet_01v8 w=1 l=0.15 ad=0.29 as=0.29 pd=2.58 ps=2.58
xc.x2.xla.x1.xmp2 0 0 0 0 sky130_fd_pr__pfet_01v8 w=1 l=0.15 ad=0.29 as=0.29 pd=2.58 ps=2.58
xc.x2.xla.x1.xmn1 0 0 0 0 sky130_fd_pr__nfet_01v8 w=0.84 l=0.15 ad=0.2436 as=0.2436 pd=2.26 ps=2.26
xc.x2.xla.x1.xmn2 0 0 0 0 sky130_fd_pr__nfet_01v8 w=0.84 l=0.15 ad=0.2436 as=0.2436 pd=2.26 ps=2.26
xc.x2.xla.x2.xmp1 0 0 0 0 sky130_fd_pr__pfet_01v8 w=1 l=0.15 ad=0.29 as=0.29 pd=2.58 ps=2.58
xc.x2.xla.x2.xmp2 0 0 0 0 sky130_fd_pr__pfet_01v8 w=1 l=0.15 ad=0.29 as=0.29 pd=2.58 ps=2.58
xc.x2.xla.x2.xmn1 0 0 0 0 sky130_fd_pr__nfet_01v8 w=0.84 l=0.15 ad=0.2436 as=0.2436 pd=2.26 ps=2.26
xc.x2.xla.x2.xmn2 0 0 0 0 sky130_fd_pr__nfet_01v8 w=0.84 l=0.15 ad=0.2436 as=0.2436 pd=2.26 ps=2.26
xc.x2.xia1.xmp 0 0 0 0 sky130_fd_pr__pfet_01v8 w=1 l=0.15 ad=0.29 as=0.29 pd=2.58 ps=2.58
xc.x2.xia1.xmn 0 0 0 0 sky130_fd_pr__nfet_01v8 w=0.42 l=0.15 ad=0.1218 as=0.1218 pd=1.42 ps=1.42
xc.x2.xia2.xmp 0 0 0 0 sky130_fd_pr__pfet_01v8 w=1 l=0.15 ad=0.29 as=0.29 pd=2.58 ps=2.58
xc.x2.xia2.xmn 0 0 0 0 sky130_fd_pr__nfet_01v8 w=0.42 l=0.15 ad=0.1218 as=0.1218 pd=1.42 ps=1.42
xc.x2.xnsc.xmp1 0 0 0 0 sky130_fd_pr__pfet_01v8 w=1 l=0.15 ad=0.29 as=0.29 pd=2.58 ps=2.58
xc.x2.xnsc.xmp2 0 0 0 0 sky130_fd_pr__pfet_01v8 w=1 l=0.15 ad=0.29 as=0.29 pd=2.58 ps=2.58
xc.x2.xnsc.xmn1 0 0 0 0 sky130_fd_pr__nfet_01v8 w=0.84 l=0.15 ad=0.2436 as=0.2436 pd=2.26 ps=2.26
xc.x2.xnsc.xmn2 0 0 0 0 sky130_fd_pr__nfet_01v8 w=0.84 l=0.15 ad=0.2436 as=0.2436 pd=2.26 ps=2.26
xc.x2.xlc.x1.xmp1 0 0 0 0 sky130_fd_pr__pfet_01v8 w=1 l=0.15 ad=0.29 as=0.29 pd=2.58 ps=2.58
xc.x2.xlc.x1.xmp2 0 0 0 0 sky130_fd_pr__pfet_01v8 w=1 l=0.15 ad=0.29 as=0.29 pd=2.58 ps=2.58
xc.x2.xlc.x1.xmn1 0 0 0 0 sky130_fd_pr__nfet_01v8 w=0.84 l=0.15 ad=0.2436 as=0.2436 pd=2.26 ps=2.26
xc.x2.xlc.x1.xmn2 0 0 0 0 sky130_fd_pr__nfet_01v8 w=0.84 l=0.15 ad=0.2436 as=0.2436 pd=2.26 ps=2.26
xc.x2.xlc.x2.xmp1 0 0 0 0 sky130_fd_pr__pfet_01v8 w=1 l=0.15 ad=0.29 as=0.29 pd=2.58 ps=2.58
xc.x2.xlc.x2.xmp2 0 0 0 0 sky130_fd_pr__pfet_01v8 w=1 l=0.15 ad=0.29 as=0.29 pd=2.58 ps=2.58
xc.x2.xlc.x2.xmn1 0 0 0 0 sky130_fd_pr__nfet_01v8 w=0.84 l=0.15 ad=0.2436 as=0.2436 pd=2.26 ps=2.26
xc.x2.xlc.x2.xmn2 0 0 0 0 sky130_fd_pr__nfet_01v8 w=0.84 l=0.15 ad=0.2436 as=0.2436 pd=2.26 ps=2.26
xc.x2.xid1.xmp 0 0 0 0 sky130_fd_pr__pfet_01v8 w=1 l=0.15 ad=0.29 as=0.29 pd=2.58 ps=2.58
xc.x2.xid1.xmn 0 0 0 0 sky130_fd_pr__nfet_01v8 w=0.42 l=0.15 ad=0.1218 as=0.1218 pd=1.42 ps=1.42
xc.x2.xid2.xmp 0 0 0 0 sky130_fd_pr__pfet_01v8 w=1 l=0.15 ad=0.29 as=0.29 pd=2.58 ps=2.58
xc.x2.xid2.xmn 0 0 0 0 sky130_fd_pr__nfet_01v8 w=0.42 l=0.15 ad=0.1218 as=0.1218 pd=1.42 ps=1.42
xc.x2.xnsb.xmp1 0 0 0 0 sky130_fd_pr__pfet_01v8 w=1 l=0.15 ad=0.29 as=0.29 pd=2.58 ps=2.58
xc.x2.xnsb.xmp2 0 0 0 0 sky130_fd_pr__pfet_01v8 w=1 l=0.15 ad=0.29 as=0.29 pd=2.58 ps=2.58
xc.x2.xnsb.xmn1 0 0 0 0 sky130_fd_pr__nfet_01v8 w=0.84 l=0.15 ad=0.2436 as=0.2436 pd=2.26 ps=2.26
xc.x2.xnsb.xmn2 0 0 0 0 sky130_fd_pr__nfet_01v8 w=0.84 l=0.15 ad=0.2436 as=0.2436 pd=2.26 ps=2.26
xc.x2.xlb.x1.xmp1 0 0 0 0 sky130_fd_pr__pfet_01v8 w=1 l=0.15 ad=0.29 as=0.29 pd=2.58 ps=2.58
xc.x2.xlb.x1.xmp2 0 0 0 0 sky130_fd_pr__pfet_01v8 w=1 l=0.15 ad=0.29 as=0.29 pd=2.58 ps=2.58
xc.x2.xlb.x1.xmn1 0 0 0 0 sky130_fd_pr__nfet_01v8 w=0.84 l=0.15 ad=0.2436 as=0.2436 pd=2.26 ps=2.26
xc.x2.xlb.x1.xmn2 0 0 0 0 sky130_fd_pr__nfet_01v8 w=0.84 l=0.15 ad=0.2436 as=0.2436 pd=2.26 ps=2.26
xc.x2.xlb.x2.xmp1 0 0 0 0 sky130_fd_pr__pfet_01v8 w=1 l=0.15 ad=0.29 as=0.29 pd=2.58 ps=2.58
xc.x2.xlb.x2.xmp2 0 0 0 0 sky130_fd_pr__pfet_01v8 w=1 l=0.15 ad=0.29 as=0.29 pd=2.58 ps=2.58
xc.x2.xlb.x2.xmn1 0 0 0 0 sky130_fd_pr__nfet_01v8 w=0.84 l=0.15 ad=0.2436 as=0.2436 pd=2.26 ps=2.26
xc.x2.xlb.x2.xmn2 0 0 0 0 sky130_fd_pr__nfet_01v8 w=0.84 l=0.15 ad=0.2436 as=0.2436 pd=2.26 ps=2.26
xc.x2.xnsi.xmp1 0 0 0 0 sky130_fd_pr__pfet_01v8 w=1 l=0.15 ad=0.29 as=0.29 pd=2.58 ps=2.58
xc.x2.xnsi.xmp2 0 0 0 0 sky130_fd_pr__pfet_01v8 w=1 l=0.15 ad=0.29 as=0.29 pd=2.58 ps=2.58
xc.x2.xnsi.xmp3 0 0 0 0 sky130_fd_pr__pfet_01v8 w=1 l=0.15 ad=0.29 as=0.29 pd=2.58 ps=2.58
xc.x2.xnsi.xmn1 0 0 0 0 sky130_fd_pr__nfet_01v8 w=1.26 l=0.15 ad=0.3654 as=0.3654 pd=3.1 ps=3.1
xc.x2.xnsi.xmn2 0 0 0 0 sky130_fd_pr__nfet_01v8 w=1.26 l=0.15 ad=0.3654 as=0.3654 pd=3.1 ps=3.1
xc.x2.xnsi.xmn3 0 0 0 0 sky130_fd_pr__nfet_01v8 w=1.26 l=0.15 ad=0.3654 as=0.3654 pd=3.1 ps=3.1
xc.x2.xisi.xmp 0 0 0 0 sky130_fd_pr__pfet_01v8 w=1 l=0.15 ad=0.29 as=0.29 pd=2.58 ps=2.58
xc.x2.xisi.xmn 0 0 0 0 sky130_fd_pr__nfet_01v8 w=0.42 l=0.15 ad=0.1218 as=0.1218 pd=1.42 ps=1.42
xc.x2.xisd.xmp 0 0 0 0 sky130_fd_pr__pfet_01v8 w=1 l=0.15 ad=0.29 as=0.29 pd=2.58 ps=2.58
xc.x2.xisd.xmn 0 0 0 0 sky130_fd_pr__nfet_01v8 w=0.42 l=0.15 ad=0.1218 as=0.1218 pd=1.42 ps=1.42
xc.xcmpm.xmb 0 0 0 0 sky130_fd_pr__pfet_01v8 w=8 l=2 ad=2.32 as=2.32 pd=16.58 ps=16.58
xc.xcmpm.xmt 0 0 0 0 sky130_fd_pr__pfet_01v8 w=16 l=2 ad=3.48 as=3.48 pd=24.87 ps=24.87
xc.xcmpm.xm1 0 0 0 0 sky130_fd_pr__pfet_01v8_lvt w={(16)} l={(4)} ad=3.48 as=3.48 pd=24.87 ps=24.87
xc.xcmpm.xm2 0 0 0 0 sky130_fd_pr__pfet_01v8_lvt w={(16)} l={(4)} ad=3.48 as=3.48 pd=24.87 ps=24.87
xc.xcmpm.xm3 0 0 0 0 sky130_fd_pr__nfet_01v8 w=2 l=1 ad=0.58 as=0.58 pd=4.58 ps=4.58
xc.xcmpm.xm4 0 0 0 0 sky130_fd_pr__nfet_01v8 w=2 l=1 ad=0.58 as=0.58 pd=4.58 ps=4.58
xc.xcmpm.xm5 0 0 0 0 sky130_fd_pr__nfet_01v8 w=2 l=0.5 ad=0.58 as=0.58 pd=4.58 ps=4.58
xc.xcmpm.xm6 0 0 0 0 sky130_fd_pr__pfet_01v8 w=16 l=2 ad=3.48 as=3.48 pd=24.87 ps=24.87
xc.xcmpm.xi1.xmp 0 0 0 0 sky130_fd_pr__pfet_01v8 w=1 l=0.15 ad=0.29 as=0.29 pd=2.58 ps=2.58
xc.xcmpm.xi1.xmn 0 0 0 0 sky130_fd_pr__nfet_01v8 w=0.42 l=0.15 ad=0.1218 as=0.1218 pd=1.42 ps=1.42
xc.xcmpm.xi2.xmp 0 0 0 0 sky130_fd_pr__pfet_01v8 w=1 l=0.15 ad=0.29 as=0.29 pd=2.58 ps=2.58
xc.xcmpm.xi2.xmn 0 0 0 0 sky130_fd_pr__nfet_01v8 w=0.42 l=0.15 ad=0.1218 as=0.1218 pd=1.42 ps=1.42
xc.xicm.xmp 0 0 0 0 sky130_fd_pr__pfet_01v8 w=1 l=0.15 ad=0.29 as=0.29 pd=2.58 ps=2.58
xc.xicm.xmn 0 0 0 0 sky130_fd_pr__nfet_01v8 w=0.42 l=0.15 ad=0.1218 as=0.1218 pd=1.42 ps=1.42
xc.xnsp.xmp1 0 0 0 0 sky130_fd_pr__pfet_01v8 w=1 l=0.15 ad=0.29 as=0.29 pd=2.58 ps=2.58
xc.xnsp.xmp2 0 0 0 0 sky130_fd_pr__pfet_01v8 w=1 l=0.15 ad=0.29 as=0.29 pd=2.58 ps=2.58
xc.xnsp.xmn1 0 0 0 0 sky130_fd_pr__nfet_01v8 w=0.84 l=0.15 ad=0.2436 as=0.2436 pd=2.26 ps=2.26
xc.xnsp.xmn2 0 0 0 0 sky130_fd_pr__nfet_01v8 w=0.84 l=0.15 ad=0.2436 as=0.2436 pd=2.26 ps=2.26
xc.xnrp.xmp1 0 0 0 0 sky130_fd_pr__pfet_01v8 w=1 l=0.15 ad=0.29 as=0.29 pd=2.58 ps=2.58
xc.xnrp.xmp2 0 0 0 0 sky130_fd_pr__pfet_01v8 w=1 l=0.15 ad=0.29 as=0.29 pd=2.58 ps=2.58
xc.xnrp.xmn1 0 0 0 0 sky130_fd_pr__nfet_01v8 w=0.84 l=0.15 ad=0.2436 as=0.2436 pd=2.26 ps=2.26
xc.xnrp.xmn2 0 0 0 0 sky130_fd_pr__nfet_01v8 w=0.84 l=0.15 ad=0.2436 as=0.2436 pd=2.26 ps=2.26
xc.xlp.x1.xmp1 0 0 0 0 sky130_fd_pr__pfet_01v8 w=1 l=0.15 ad=0.29 as=0.29 pd=2.58 ps=2.58
xc.xlp.x1.xmp2 0 0 0 0 sky130_fd_pr__pfet_01v8 w=1 l=0.15 ad=0.29 as=0.29 pd=2.58 ps=2.58
xc.xlp.x1.xmn1 0 0 0 0 sky130_fd_pr__nfet_01v8 w=0.84 l=0.15 ad=0.2436 as=0.2436 pd=2.26 ps=2.26
xc.xlp.x1.xmn2 0 0 0 0 sky130_fd_pr__nfet_01v8 w=0.84 l=0.15 ad=0.2436 as=0.2436 pd=2.26 ps=2.26
xc.xlp.x2.xmp1 0 0 0 0 sky130_fd_pr__pfet_01v8 w=1 l=0.15 ad=0.29 as=0.29 pd=2.58 ps=2.58
xc.xlp.x2.xmp2 0 0 0 0 sky130_fd_pr__pfet_01v8 w=1 l=0.15 ad=0.29 as=0.29 pd=2.58 ps=2.58
xc.xlp.x2.xmn1 0 0 0 0 sky130_fd_pr__nfet_01v8 w=0.84 l=0.15 ad=0.2436 as=0.2436 pd=2.26 ps=2.26
xc.xlp.x2.xmn2 0 0 0 0 sky130_fd_pr__nfet_01v8 w=0.84 l=0.15 ad=0.2436 as=0.2436 pd=2.26 ps=2.26
xc.xip1.xmp 0 0 0 0 sky130_fd_pr__pfet_01v8 w=1 l=0.15 ad=0.29 as=0.29 pd=2.58 ps=2.58
xc.xip1.xmn 0 0 0 0 sky130_fd_pr__nfet_01v8 w=0.42 l=0.15 ad=0.1218 as=0.1218 pd=1.42 ps=1.42
xc.xip2.xmp 0 0 0 0 sky130_fd_pr__pfet_01v8 w=1 l=0.15 ad=0.29 as=0.29 pd=2.58 ps=2.58
xc.xip2.xmn 0 0 0 0 sky130_fd_pr__nfet_01v8 w=0.42 l=0.15 ad=0.1218 as=0.1218 pd=1.42 ps=1.42
xc.xmm1n 0 0 0 0 sky130_fd_pr__nfet_01v8 w=1 l=0.15 ad=0.29 as=0.29 pd=2.58 ps=2.58
xc.xmm1p 0 0 0 0 sky130_fd_pr__pfet_01v8 w=2 l=0.15 ad=0.58 as=0.58 pd=4.58 ps=4.58
xc.xmm2n 0 0 0 0 sky130_fd_pr__nfet_01v8 w=1 l=0.15 ad=0.29 as=0.29 pd=2.58 ps=2.58
xc.xmm2p 0 0 0 0 sky130_fd_pr__pfet_01v8 w=2 l=0.15 ad=0.58 as=0.58 pd=4.58 ps=4.58
.option temp=27
vgl gl 0 dc 0
vfpb xb.p 0 dc 0
vfpbb xb.pb 0 dc 1.8
vfrc xb.x1.vs 0 dc 0.598677
r.cond28 xb.x1.xla.x1.n1 0 1e12 noisy=0
r.cond29 xb.x1.xla.x2.n1 0 1e12 noisy=0
r.cond30 xb.x1.xlb.x1.n1 0 1e12 noisy=0
r.cond31 xb.x1.xlb.x2.n1 0 1e12 noisy=0
r.cond32 xb.x1.xlc.x1.n1 0 1e12 noisy=0
r.cond33 xb.x1.xlc.x2.n1 0 1e12 noisy=0
r.cond34 xb.x1.xnad.n1 0 1e12 noisy=0
r.cond35 xb.x1.xnsa.n1 0 1e12 noisy=0
r.cond36 xb.x1.xnsb.n1 0 1e12 noisy=0
r.cond37 xb.x1.xnsc.n1 0 1e12 noisy=0
r.cond38 xb.x1.xnsi.n1 0 1e12 noisy=0
r.cond39 xb.x1.xnsi.n2 0 1e12 noisy=0
r.cond40 xb.x2.xla.x1.n1 0 1e12 noisy=0
r.cond41 xb.x2.xla.x2.n1 0 1e12 noisy=0
r.cond42 xb.x2.xlb.x1.n1 0 1e12 noisy=0
r.cond43 xb.x2.xlb.x2.n1 0 1e12 noisy=0
r.cond44 xb.x2.xlc.x1.n1 0 1e12 noisy=0
r.cond45 xb.x2.xlc.x2.n1 0 1e12 noisy=0
r.cond46 xb.x2.xnad.n1 0 1e12 noisy=0
r.cond47 xb.x2.xnsa.n1 0 1e12 noisy=0
r.cond48 xb.x2.xnsb.n1 0 1e12 noisy=0
r.cond49 xb.x2.xnsc.n1 0 1e12 noisy=0
r.cond50 xb.x2.xnsi.n1 0 1e12 noisy=0
r.cond51 xb.x2.xnsi.n2 0 1e12 noisy=0
r.cond52 xb.xlp.x1.n1 0 1e12 noisy=0
r.cond53 xb.xlp.x2.n1 0 1e12 noisy=0
r.cond54 xb.xnrp.n1 0 1e12 noisy=0
r.cond55 xb.xnsp.n1 0 1e12 noisy=0
iinj0 xb.x1.xcmps.o1m xb.x1.xcmps.tail dc 0 ac 0
iinj1 xb.x1.xcmps.o1 xb.x1.xcmps.tail dc 0 ac 0
iinj2 xb.x1.xcmps.o1m 0 dc 0 ac 0
iinj3 xb.x1.xcmps.o1 0 dc 0 ac 0
iinj4 xb.x1.xcmps.o2 0 dc 0 ac 0
iinj5 xb.x1.xcmps.o2 vdd dc 0 ac 0
iinj6 xb.x1.ibs vdd dc 0 ac 0
iinj7 xb.x1.xcmps.tail vdd dc 0 ac 0
iinj8 xb.x1.vgd vcm dc 0 ac 0
iinj9 xb.x1.vs xb.x1.x dc 0 ac 0
iinj10 xb.x1.gm vcm dc 0 ac 0
iinj11 xb.x1.dq xb.vmem1 dc 0 ac 0
iinj12 xb.x1.vs vpre dc 0 ac 0
iinj13 xb.x1.vrefs vhi dc 0 ac 0
iinj14 xb.x1.vrefs vhi dc 0 ac 0
iinj15 xb.x1.vrefs vlo dc 0 ac 0
iinj16 xb.x1.vrefs vlo dc 0 ac 0
iinj17 xb.x1.dq xb.vq dc 0 ac 0
iinj18 xb.x1.dq vr0 dc 0 ac 0
iinj19 xb.x1.x vcm dc 0 ac 0
iinj20 xb.x1.x xb.x1.sum dc 0 ac 0
iinj21 xb.x1.xop.o1m xb.x1.xop.tail dc 0 ac 0
iinj22 xb.x1.xop.o1 xb.x1.xop.tail dc 0 ac 0
iinj23 xb.x1.xop.o1m 0 dc 0 ac 0
iinj24 xb.x1.xop.o1 0 dc 0 ac 0
iinj25 xb.vmem1 0 dc 0 ac 0
iinj26 xb.vmem1 vdd dc 0 ac 0
iinj27 xb.x1.ibo vdd dc 0 ac 0
iinj28 xb.x1.xop.tail vdd dc 0 ac 0
iinj29 xb.x2.xcmps.o1m xb.x2.xcmps.tail dc 0 ac 0
iinj30 xb.x2.xcmps.o1 xb.x2.xcmps.tail dc 0 ac 0
iinj31 xb.x2.xcmps.o1m 0 dc 0 ac 0
iinj32 xb.x2.xcmps.o1 0 dc 0 ac 0
iinj33 xb.x2.xcmps.o2 0 dc 0 ac 0
iinj34 xb.x2.xcmps.o2 vdd dc 0 ac 0
iinj35 xb.x2.ibs vdd dc 0 ac 0
iinj36 xb.x2.xcmps.tail vdd dc 0 ac 0
iinj37 xb.x2.vgd vcm dc 0 ac 0
iinj38 xb.x2.vs xb.x2.x dc 0 ac 0
iinj39 xb.x2.gm vcm dc 0 ac 0
iinj40 xb.x2.dq xb.vmem2 dc 0 ac 0
iinj41 xb.x2.vs vpre dc 0 ac 0
iinj42 xb.x2.vrefs vhi dc 0 ac 0
iinj43 xb.x2.vrefs vhi dc 0 ac 0
iinj44 xb.x2.vrefs vlo dc 0 ac 0
iinj45 xb.x2.vrefs vlo dc 0 ac 0
iinj46 xb.x2.dq xb.vq dc 0 ac 0
iinj47 xb.x2.dq vr0 dc 0 ac 0
iinj48 xb.x2.x vcm dc 0 ac 0
iinj49 xb.x2.x xb.x2.sum dc 0 ac 0
iinj50 xb.x2.xop.o1m xb.x2.xop.tail dc 0 ac 0
iinj51 xb.x2.xop.o1 xb.x2.xop.tail dc 0 ac 0
iinj52 xb.x2.xop.o1m 0 dc 0 ac 0
iinj53 xb.x2.xop.o1 0 dc 0 ac 0
iinj54 xb.vmem2 0 dc 0 ac 0
iinj55 xb.vmem2 vdd dc 0 ac 0
iinj56 xb.x2.ibo vdd dc 0 ac 0
iinj57 xb.x2.xop.tail vdd dc 0 ac 0
iinj58 xb.xcmpm.o1m xb.xcmpm.tail dc 0 ac 0
iinj59 xb.xcmpm.o1 xb.xcmpm.tail dc 0 ac 0
iinj60 xb.xcmpm.o1m 0 dc 0 ac 0
iinj61 xb.xcmpm.o1 0 dc 0 ac 0
iinj62 xb.xcmpm.o2 0 dc 0 ac 0
iinj63 xb.xcmpm.o2 vdd dc 0 ac 0
iinj64 xb.ibm vdd dc 0 ac 0
iinj65 xb.xcmpm.tail vdd dc 0 ac 0
iinj66 xb.vrefm vfire dc 0 ac 0
iinj67 xb.vrefm vfire dc 0 ac 0
iinj68 xb.vrefm vreopen dc 0 ac 0
iinj69 xb.vrefm vreopen dc 0 ac 0
iinj70 xb.x1.xop.o1 xb.x1.xop.oz dc 0 ac 0
iinj71 xb.x1.a xb.x1.ad1 dc 0 ac 0
iinj72 xb.x1.c xb.x1.cd1 dc 0 ac 0
iinj73 xb.x2.xop.o1 xb.x2.xop.oz dc 0 ac 0
iinj74 xb.x2.a xb.x2.ad1 dc 0 ac 0
iinj75 xb.x2.c xb.x2.cd1 dc 0 ac 0
iinj76 xb.vq vr0 dc 0 ac 0
iinj77 xb.p xb.pd1 dc 0 ac 0
.control
set numdgt=16
set filetype=ascii
alter @iinj0[acmag]=1
ac dec 20 1 1e8
let h0 = mag(v(xb.x1.xcmps.o1))
write h0.raw h0
alter @iinj0[acmag]=0
alter @iinj1[acmag]=1
ac dec 20 1 1e8
let h1 = mag(v(xb.x1.xcmps.o1))
write h1.raw h1
alter @iinj1[acmag]=0
alter @iinj2[acmag]=1
ac dec 20 1 1e8
let h2 = mag(v(xb.x1.xcmps.o1))
write h2.raw h2
alter @iinj2[acmag]=0
alter @iinj3[acmag]=1
ac dec 20 1 1e8
let h3 = mag(v(xb.x1.xcmps.o1))
write h3.raw h3
alter @iinj3[acmag]=0
alter @iinj4[acmag]=1
ac dec 20 1 1e8
let h4 = mag(v(xb.x1.xcmps.o1))
write h4.raw h4
alter @iinj4[acmag]=0
alter @iinj5[acmag]=1
ac dec 20 1 1e8
let h5 = mag(v(xb.x1.xcmps.o1))
write h5.raw h5
alter @iinj5[acmag]=0
alter @iinj6[acmag]=1
ac dec 20 1 1e8
let h6 = mag(v(xb.x1.xcmps.o1))
write h6.raw h6
alter @iinj6[acmag]=0
alter @iinj7[acmag]=1
ac dec 20 1 1e8
let h7 = mag(v(xb.x1.xcmps.o1))
write h7.raw h7
alter @iinj7[acmag]=0
alter @iinj8[acmag]=1
ac dec 20 1 1e8
let h8 = mag(v(xb.x1.xcmps.o1))
write h8.raw h8
alter @iinj8[acmag]=0
alter @iinj9[acmag]=1
ac dec 20 1 1e8
let h9 = mag(v(xb.x1.xcmps.o1))
write h9.raw h9
alter @iinj9[acmag]=0
alter @iinj10[acmag]=1
ac dec 20 1 1e8
let h10 = mag(v(xb.x1.xcmps.o1))
write h10.raw h10
alter @iinj10[acmag]=0
alter @iinj11[acmag]=1
ac dec 20 1 1e8
let h11 = mag(v(xb.x1.xcmps.o1))
write h11.raw h11
alter @iinj11[acmag]=0
alter @iinj12[acmag]=1
ac dec 20 1 1e8
let h12 = mag(v(xb.x1.xcmps.o1))
write h12.raw h12
alter @iinj12[acmag]=0
alter @iinj13[acmag]=1
ac dec 20 1 1e8
let h13 = mag(v(xb.x1.xcmps.o1))
write h13.raw h13
alter @iinj13[acmag]=0
alter @iinj14[acmag]=1
ac dec 20 1 1e8
let h14 = mag(v(xb.x1.xcmps.o1))
write h14.raw h14
alter @iinj14[acmag]=0
alter @iinj15[acmag]=1
ac dec 20 1 1e8
let h15 = mag(v(xb.x1.xcmps.o1))
write h15.raw h15
alter @iinj15[acmag]=0
alter @iinj16[acmag]=1
ac dec 20 1 1e8
let h16 = mag(v(xb.x1.xcmps.o1))
write h16.raw h16
alter @iinj16[acmag]=0
alter @iinj17[acmag]=1
ac dec 20 1 1e8
let h17 = mag(v(xb.x1.xcmps.o1))
write h17.raw h17
alter @iinj17[acmag]=0
alter @iinj18[acmag]=1
ac dec 20 1 1e8
let h18 = mag(v(xb.x1.xcmps.o1))
write h18.raw h18
alter @iinj18[acmag]=0
alter @iinj19[acmag]=1
ac dec 20 1 1e8
let h19 = mag(v(xb.x1.xcmps.o1))
write h19.raw h19
alter @iinj19[acmag]=0
alter @iinj20[acmag]=1
ac dec 20 1 1e8
let h20 = mag(v(xb.x1.xcmps.o1))
write h20.raw h20
alter @iinj20[acmag]=0
alter @iinj21[acmag]=1
ac dec 20 1 1e8
let h21 = mag(v(xb.x1.xcmps.o1))
write h21.raw h21
alter @iinj21[acmag]=0
alter @iinj22[acmag]=1
ac dec 20 1 1e8
let h22 = mag(v(xb.x1.xcmps.o1))
write h22.raw h22
alter @iinj22[acmag]=0
alter @iinj23[acmag]=1
ac dec 20 1 1e8
let h23 = mag(v(xb.x1.xcmps.o1))
write h23.raw h23
alter @iinj23[acmag]=0
alter @iinj24[acmag]=1
ac dec 20 1 1e8
let h24 = mag(v(xb.x1.xcmps.o1))
write h24.raw h24
alter @iinj24[acmag]=0
alter @iinj25[acmag]=1
ac dec 20 1 1e8
let h25 = mag(v(xb.x1.xcmps.o1))
write h25.raw h25
alter @iinj25[acmag]=0
alter @iinj26[acmag]=1
ac dec 20 1 1e8
let h26 = mag(v(xb.x1.xcmps.o1))
write h26.raw h26
alter @iinj26[acmag]=0
alter @iinj27[acmag]=1
ac dec 20 1 1e8
let h27 = mag(v(xb.x1.xcmps.o1))
write h27.raw h27
alter @iinj27[acmag]=0
alter @iinj28[acmag]=1
ac dec 20 1 1e8
let h28 = mag(v(xb.x1.xcmps.o1))
write h28.raw h28
alter @iinj28[acmag]=0
alter @iinj29[acmag]=1
ac dec 20 1 1e8
let h29 = mag(v(xb.x1.xcmps.o1))
write h29.raw h29
alter @iinj29[acmag]=0
alter @iinj30[acmag]=1
ac dec 20 1 1e8
let h30 = mag(v(xb.x1.xcmps.o1))
write h30.raw h30
alter @iinj30[acmag]=0
alter @iinj31[acmag]=1
ac dec 20 1 1e8
let h31 = mag(v(xb.x1.xcmps.o1))
write h31.raw h31
alter @iinj31[acmag]=0
alter @iinj32[acmag]=1
ac dec 20 1 1e8
let h32 = mag(v(xb.x1.xcmps.o1))
write h32.raw h32
alter @iinj32[acmag]=0
alter @iinj33[acmag]=1
ac dec 20 1 1e8
let h33 = mag(v(xb.x1.xcmps.o1))
write h33.raw h33
alter @iinj33[acmag]=0
alter @iinj34[acmag]=1
ac dec 20 1 1e8
let h34 = mag(v(xb.x1.xcmps.o1))
write h34.raw h34
alter @iinj34[acmag]=0
alter @iinj35[acmag]=1
ac dec 20 1 1e8
let h35 = mag(v(xb.x1.xcmps.o1))
write h35.raw h35
alter @iinj35[acmag]=0
alter @iinj36[acmag]=1
ac dec 20 1 1e8
let h36 = mag(v(xb.x1.xcmps.o1))
write h36.raw h36
alter @iinj36[acmag]=0
alter @iinj37[acmag]=1
ac dec 20 1 1e8
let h37 = mag(v(xb.x1.xcmps.o1))
write h37.raw h37
alter @iinj37[acmag]=0
alter @iinj38[acmag]=1
ac dec 20 1 1e8
let h38 = mag(v(xb.x1.xcmps.o1))
write h38.raw h38
alter @iinj38[acmag]=0
alter @iinj39[acmag]=1
ac dec 20 1 1e8
let h39 = mag(v(xb.x1.xcmps.o1))
write h39.raw h39
alter @iinj39[acmag]=0
alter @iinj40[acmag]=1
ac dec 20 1 1e8
let h40 = mag(v(xb.x1.xcmps.o1))
write h40.raw h40
alter @iinj40[acmag]=0
alter @iinj41[acmag]=1
ac dec 20 1 1e8
let h41 = mag(v(xb.x1.xcmps.o1))
write h41.raw h41
alter @iinj41[acmag]=0
alter @iinj42[acmag]=1
ac dec 20 1 1e8
let h42 = mag(v(xb.x1.xcmps.o1))
write h42.raw h42
alter @iinj42[acmag]=0
alter @iinj43[acmag]=1
ac dec 20 1 1e8
let h43 = mag(v(xb.x1.xcmps.o1))
write h43.raw h43
alter @iinj43[acmag]=0
alter @iinj44[acmag]=1
ac dec 20 1 1e8
let h44 = mag(v(xb.x1.xcmps.o1))
write h44.raw h44
alter @iinj44[acmag]=0
alter @iinj45[acmag]=1
ac dec 20 1 1e8
let h45 = mag(v(xb.x1.xcmps.o1))
write h45.raw h45
alter @iinj45[acmag]=0
alter @iinj46[acmag]=1
ac dec 20 1 1e8
let h46 = mag(v(xb.x1.xcmps.o1))
write h46.raw h46
alter @iinj46[acmag]=0
alter @iinj47[acmag]=1
ac dec 20 1 1e8
let h47 = mag(v(xb.x1.xcmps.o1))
write h47.raw h47
alter @iinj47[acmag]=0
alter @iinj48[acmag]=1
ac dec 20 1 1e8
let h48 = mag(v(xb.x1.xcmps.o1))
write h48.raw h48
alter @iinj48[acmag]=0
alter @iinj49[acmag]=1
ac dec 20 1 1e8
let h49 = mag(v(xb.x1.xcmps.o1))
write h49.raw h49
alter @iinj49[acmag]=0
alter @iinj50[acmag]=1
ac dec 20 1 1e8
let h50 = mag(v(xb.x1.xcmps.o1))
write h50.raw h50
alter @iinj50[acmag]=0
alter @iinj51[acmag]=1
ac dec 20 1 1e8
let h51 = mag(v(xb.x1.xcmps.o1))
write h51.raw h51
alter @iinj51[acmag]=0
alter @iinj52[acmag]=1
ac dec 20 1 1e8
let h52 = mag(v(xb.x1.xcmps.o1))
write h52.raw h52
alter @iinj52[acmag]=0
alter @iinj53[acmag]=1
ac dec 20 1 1e8
let h53 = mag(v(xb.x1.xcmps.o1))
write h53.raw h53
alter @iinj53[acmag]=0
alter @iinj54[acmag]=1
ac dec 20 1 1e8
let h54 = mag(v(xb.x1.xcmps.o1))
write h54.raw h54
alter @iinj54[acmag]=0
alter @iinj55[acmag]=1
ac dec 20 1 1e8
let h55 = mag(v(xb.x1.xcmps.o1))
write h55.raw h55
alter @iinj55[acmag]=0
alter @iinj56[acmag]=1
ac dec 20 1 1e8
let h56 = mag(v(xb.x1.xcmps.o1))
write h56.raw h56
alter @iinj56[acmag]=0
alter @iinj57[acmag]=1
ac dec 20 1 1e8
let h57 = mag(v(xb.x1.xcmps.o1))
write h57.raw h57
alter @iinj57[acmag]=0
alter @iinj58[acmag]=1
ac dec 20 1 1e8
let h58 = mag(v(xb.x1.xcmps.o1))
write h58.raw h58
alter @iinj58[acmag]=0
alter @iinj59[acmag]=1
ac dec 20 1 1e8
let h59 = mag(v(xb.x1.xcmps.o1))
write h59.raw h59
alter @iinj59[acmag]=0
alter @iinj60[acmag]=1
ac dec 20 1 1e8
let h60 = mag(v(xb.x1.xcmps.o1))
write h60.raw h60
alter @iinj60[acmag]=0
alter @iinj61[acmag]=1
ac dec 20 1 1e8
let h61 = mag(v(xb.x1.xcmps.o1))
write h61.raw h61
alter @iinj61[acmag]=0
alter @iinj62[acmag]=1
ac dec 20 1 1e8
let h62 = mag(v(xb.x1.xcmps.o1))
write h62.raw h62
alter @iinj62[acmag]=0
alter @iinj63[acmag]=1
ac dec 20 1 1e8
let h63 = mag(v(xb.x1.xcmps.o1))
write h63.raw h63
alter @iinj63[acmag]=0
alter @iinj64[acmag]=1
ac dec 20 1 1e8
let h64 = mag(v(xb.x1.xcmps.o1))
write h64.raw h64
alter @iinj64[acmag]=0
alter @iinj65[acmag]=1
ac dec 20 1 1e8
let h65 = mag(v(xb.x1.xcmps.o1))
write h65.raw h65
alter @iinj65[acmag]=0
alter @iinj66[acmag]=1
ac dec 20 1 1e8
let h66 = mag(v(xb.x1.xcmps.o1))
write h66.raw h66
alter @iinj66[acmag]=0
alter @iinj67[acmag]=1
ac dec 20 1 1e8
let h67 = mag(v(xb.x1.xcmps.o1))
write h67.raw h67
alter @iinj67[acmag]=0
alter @iinj68[acmag]=1
ac dec 20 1 1e8
let h68 = mag(v(xb.x1.xcmps.o1))
write h68.raw h68
alter @iinj68[acmag]=0
alter @iinj69[acmag]=1
ac dec 20 1 1e8
let h69 = mag(v(xb.x1.xcmps.o1))
write h69.raw h69
alter @iinj69[acmag]=0
alter @iinj70[acmag]=1
ac dec 20 1 1e8
let h70 = mag(v(xb.x1.xcmps.o1))
write h70.raw h70
alter @iinj70[acmag]=0
alter @iinj71[acmag]=1
ac dec 20 1 1e8
let h71 = mag(v(xb.x1.xcmps.o1))
write h71.raw h71
alter @iinj71[acmag]=0
alter @iinj72[acmag]=1
ac dec 20 1 1e8
let h72 = mag(v(xb.x1.xcmps.o1))
write h72.raw h72
alter @iinj72[acmag]=0
alter @iinj73[acmag]=1
ac dec 20 1 1e8
let h73 = mag(v(xb.x1.xcmps.o1))
write h73.raw h73
alter @iinj73[acmag]=0
alter @iinj74[acmag]=1
ac dec 20 1 1e8
let h74 = mag(v(xb.x1.xcmps.o1))
write h74.raw h74
alter @iinj74[acmag]=0
alter @iinj75[acmag]=1
ac dec 20 1 1e8
let h75 = mag(v(xb.x1.xcmps.o1))
write h75.raw h75
alter @iinj75[acmag]=0
alter @iinj76[acmag]=1
ac dec 20 1 1e8
let h76 = mag(v(xb.x1.xcmps.o1))
write h76.raw h76
alter @iinj76[acmag]=0
alter @iinj77[acmag]=1
ac dec 20 1 1e8
let h77 = mag(v(xb.x1.xcmps.o1))
write h77.raw h77
alter @iinj77[acmag]=0
op
write op_after.raw all
quit
.endc
.end
